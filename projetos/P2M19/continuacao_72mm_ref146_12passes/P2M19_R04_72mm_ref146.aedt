# Ansys Electronics Desktop project, version 2024.2
materials:
  vacuum: permittivity=1
  POM_nom: permittivity=3.4 dielectric_loss_tangent=0.01
  PTFE_terminal: permittivity=2.0363635 dielectric_loss_tangent=0.00027683055
  ZYF300: permittivity=2.94 dielectric_loss_tangent=0.0016
  RO4350B_R01: permittivity=3.66 dielectric_loss_tangent=0.0037
  AL5052: conductivity=20000000
  SAC305: conductivity=7575758
  copper: permeability=0.999991 conductivity=58000000
  NiP_vol_nominal: permeability=1 conductivity=1500000
  Ouro_vol_nominal: permeability=1 conductivity=41000000
  Cobre_vol_Groiss: permeability=1 conductivity=28688604

design P2M19_R04_72mm_ref146 (HFSS, HFSS Hybrid Modal Network, model units mm)
geometry:
  Refletor_Al2mm [AL5052] = imported_body(D:/dev/EMBRAER/P2M19/R04_72mm_ref146\cad\AL5052.step)
  C2R4_PTFE_B, C2R4_PTFE_A, C2R3_PTFE_B, C2R3_PTFE_A, C2R2_PTFE_B, C2R2_PTFE_A, C2R1_PTFE_B, C2R1_PTFE_A, C1R4_PTFE_B, C1R4_PTFE_A, C1R3_PTFE_B, C1R3_PTFE_A, C1R2_PTFE_B, C1R2_PTFE_A, C1R1_PTFE_B, C1R1_PTFE_A [PTFE_terminal] = imported_body(D:/dev/EMBRAER/P2M19/R04_72mm_ref146\cad\PTFE_terminal.step)
  C2R4_PCB_RO4350B, C2R3_PCB_RO4350B, C2R2_PCB_RO4350B, C2R1_PCB_RO4350B, C1R4_PCB_RO4350B, C1R3_PCB_RO4350B, C1R2_PCB_RO4350B, C1R1_PCB_RO4350B [RO4350B_R01] = imported_body(D:/dev/EMBRAER/P2M19/R04_72mm_ref146\cad\RO4350B_R01.step)
  C2R4_Solda_B, C2R4_Solda_A, C2R3_Solda_B, C2R3_Solda_A, C2R2_Solda_B, C2R2_Solda_A, C2R1_Solda_B, C2R1_Solda_A, C1R4_Solda_B, C1R4_Solda_A, C1R3_Solda_B, C1R3_Solda_A, C1R2_Solda_B, C1R2_Solda_A, C1R1_Solda_B, C1R1_Solda_A [SAC305] = imported_body(D:/dev/EMBRAER/P2M19/R04_72mm_ref146\cad\SAC305.step)
  C2R4_PTH_B, C2R4_Blindagem_B, C2R4_Vivo_B, C2R4_PTH_A, C2R4_Blindagem_A, C2R4_Vivo_A, C2R4_Via_7, C2R4_Via_6, C2R4_Via_5, C2R4_Via_4, C2R4_Via_3, C2R4_Via_2, C2R4_Via_1, C2R4_Via_0, C2R3_PTH_B, C2R3_Blindagem_B, C2R3_Vivo_B, C2R3_PTH_A, C2R3_Blindagem_A, C2R3_Vivo_A, C2R3_Via_7, C2R3_Via_6, C2R3_Via_5, C2R3_Via_4, C2R3_Via_3, C2R3_Via_2, C2R3_Via_1, C2R3_Via_0, C2R2_PTH_B, C2R2_Blindagem_B, C2R2_Vivo_B, C2R2_PTH_A, C2R2_Blindagem_A, C2R2_Vivo_A, C2R2_Via_7, C2R2_Via_6, C2R2_Via_5, C2R2_Via_4, C2R2_Via_3, C2R2_Via_2, C2R2_Via_1, C2R2_Via_0, C2R1_PTH_B, C2R1_Blindagem_B, C2R1_Vivo_B, C2R1_PTH_A, C2R1_Blindagem_A, C2R1_Vivo_A, C2R1_Via_7, C2R1_Via_6, C2R1_Via_5, C2R1_Via_4, C2R1_Via_3, C2R1_Via_2, C2R1_Via_1, C2R1_Via_0, C1R4_PTH_B, C1R4_Blindagem_B, C1R4_Vivo_B, C1R4_PTH_A, C1R4_Blindagem_A, C1R4_Vivo_A, C1R4_Via_7, C1R4_Via_6, C1R4_Via_5, C1R4_Via_4, C1R4_Via_3, C1R4_Via_2, C1R4_Via_1, C1R4_Via_0, C1R3_PTH_B, C1R3_Blindagem_B, C1R3_Vivo_B, C1R3_PTH_A, C1R3_Blindagem_A, C1R3_Vivo_A, C1R3_Via_7, C1R3_Via_6, C1R3_Via_5, C1R3_Via_4, C1R3_Via_3, C1R3_Via_2, C1R3_Via_1, C1R3_Via_0, C1R2_PTH_B, C1R2_Blindagem_B, C1R2_Vivo_B, C1R2_PTH_A, C1R2_Blindagem_A, C1R2_Vivo_A, C1R2_Via_7, C1R2_Via_6, C1R2_Via_5, C1R2_Via_4, C1R2_Via_3, C1R2_Via_2, C1R2_Via_1, C1R2_Via_0, C1R1_PTH_B, C1R1_Blindagem_B, C1R1_Vivo_B, C1R1_PTH_A, C1R1_Blindagem_A, C1R1_Vivo_A, C1R1_Via_7, C1R1_Via_6, C1R1_Via_5, C1R1_Via_4, C1R1_Via_3, C1R1_Via_2, C1R1_Via_1, C1R1_Via_0 [copper] = imported_body(D:/dev/EMBRAER/P2M19/R04_72mm_ref146\cad\copper.step)
  C2R4_F_SIG_B_Cu4, C2R4_F_SIG_B_Cu3, C2R4_F_SIG_B_Cu2, C2R4_F_SIG_B_Cu1, C2R4_F_SIG_B_Cu0, C2R4_F_SIG_A_Cu0, C2R4_B_SIG_B_Cu4, C2R4_B_SIG_B_Cu3, C2R4_B_SIG_B_Cu2, C2R4_B_SIG_B_Cu1, C2R4_B_SIG_B_Cu0, C2R4_B_SIG_A_Cu0, C2R4_B_RET_B_Cu0, C2R4_B_RET_A_Cu0, C2R4_B_E4_Q3_Cu0, C2R4_B_E4_Q2_Cu0, C2R4_B_E3_Q3_Cu0, C2R4_B_E3_Q2_Cu0, C2R4_B_E2_Q3_Cu0, C2R4_B_E2_Q2_Cu0, C2R4_B_E1_Q3_Cu0, C2R4_B_E1_Q2_Cu0, C2R3_F_SIG_B_Cu4, C2R3_F_SIG_B_Cu3, C2R3_F_SIG_B_Cu2, C2R3_F_SIG_B_Cu1, C2R3_F_SIG_B_Cu0, C2R3_F_SIG_A_Cu0, C2R3_B_SIG_B_Cu4, C2R3_B_SIG_B_Cu3, C2R3_B_SIG_B_Cu2, C2R3_B_SIG_B_Cu1, C2R3_B_SIG_B_Cu0, C2R3_B_SIG_A_Cu0, C2R3_B_RET_B_Cu0, C2R3_B_RET_A_Cu0, C2R3_B_E4_Q3_Cu0, C2R3_B_E4_Q2_Cu0, C2R3_B_E3_Q3_Cu0, C2R3_B_E3_Q2_Cu0, C2R3_B_E2_Q3_Cu0, C2R3_B_E2_Q2_Cu0, C2R3_B_E1_Q3_Cu0, C2R3_B_E1_Q2_Cu0, C2R2_F_SIG_B_Cu4, C2R2_F_SIG_B_Cu3, C2R2_F_SIG_B_Cu2, C2R2_F_SIG_B_Cu1, C2R2_F_SIG_B_Cu0, C2R2_F_SIG_A_Cu0, C2R2_B_SIG_B_Cu4, C2R2_B_SIG_B_Cu3, C2R2_B_SIG_B_Cu2, C2R2_B_SIG_B_Cu1, C2R2_B_SIG_B_Cu0, C2R2_B_SIG_A_Cu0, C2R2_B_RET_B_Cu0, C2R2_B_RET_A_Cu0, C2R2_B_E4_Q3_Cu0, C2R2_B_E4_Q2_Cu0, C2R2_B_E3_Q3_Cu0, C2R2_B_E3_Q2_Cu0, C2R2_B_E2_Q3_Cu0, C2R2_B_E2_Q2_Cu0, C2R2_B_E1_Q3_Cu0, C2R2_B_E1_Q2_Cu0, C2R1_F_SIG_B_Cu4, C2R1_F_SIG_B_Cu3, C2R1_F_SIG_B_Cu2, C2R1_F_SIG_B_Cu1, C2R1_F_SIG_B_Cu0, C2R1_F_SIG_A_Cu0, C2R1_B_SIG_B_Cu4, C2R1_B_SIG_B_Cu3, C2R1_B_SIG_B_Cu2, C2R1_B_SIG_B_Cu1, C2R1_B_SIG_B_Cu0, C2R1_B_SIG_A_Cu0, C2R1_B_RET_B_Cu0, C2R1_B_RET_A_Cu0, C2R1_B_E4_Q3_Cu0, C2R1_B_E4_Q2_Cu0, C2R1_B_E3_Q3_Cu0, C2R1_B_E3_Q2_Cu0, C2R1_B_E2_Q3_Cu0, C2R1_B_E2_Q2_Cu0, C2R1_B_E1_Q3_Cu0, C2R1_B_E1_Q2_Cu0, C1R4_F_SIG_B_Cu4, C1R4_F_SIG_B_Cu3, C1R4_F_SIG_B_Cu2, C1R4_F_SIG_B_Cu1, C1R4_F_SIG_B_Cu0, C1R4_F_SIG_A_Cu0, C1R4_B_SIG_B_Cu4, C1R4_B_SIG_B_Cu3, C1R4_B_SIG_B_Cu2, C1R4_B_SIG_B_Cu1, C1R4_B_SIG_B_Cu0, C1R4_B_SIG_A_Cu0, C1R4_B_RET_B_Cu0, C1R4_B_RET_A_Cu0, C1R4_B_E4_Q3_Cu0, C1R4_B_E4_Q2_Cu0, C1R4_B_E3_Q3_Cu0, C1R4_B_E3_Q2_Cu0, C1R4_B_E2_Q3_Cu0, C1R4_B_E2_Q2_Cu0, C1R4_B_E1_Q3_Cu0, C1R4_B_E1_Q2_Cu0, C1R3_F_SIG_B_Cu4, C1R3_F_SIG_B_Cu3, C1R3_F_SIG_B_Cu2, C1R3_F_SIG_B_Cu1, C1R3_F_SIG_B_Cu0, C1R3_F_SIG_A_Cu0, C1R3_B_SIG_B_Cu4, C1R3_B_SIG_B_Cu3, C1R3_B_SIG_B_Cu2, C1R3_B_SIG_B_Cu1, C1R3_B_SIG_B_Cu0, C1R3_B_SIG_A_Cu0, C1R3_B_RET_B_Cu0, C1R3_B_RET_A_Cu0, C1R3_B_E4_Q3_Cu0, C1R3_B_E4_Q2_Cu0, C1R3_B_E3_Q3_Cu0, C1R3_B_E3_Q2_Cu0, C1R3_B_E2_Q3_Cu0, C1R3_B_E2_Q2_Cu0, C1R3_B_E1_Q3_Cu0, C1R3_B_E1_Q2_Cu0, C1R2_F_SIG_B_Cu4, C1R2_F_SIG_B_Cu3, C1R2_F_SIG_B_Cu2, C1R2_F_SIG_B_Cu1, C1R2_F_SIG_B_Cu0, C1R2_F_SIG_A_Cu0, C1R2_B_SIG_B_Cu4, C1R2_B_SIG_B_Cu3, C1R2_B_SIG_B_Cu2, C1R2_B_SIG_B_Cu1, C1R2_B_SIG_B_Cu0, C1R2_B_SIG_A_Cu0, C1R2_B_RET_B_Cu0, C1R2_B_RET_A_Cu0, C1R2_B_E4_Q3_Cu0, C1R2_B_E4_Q2_Cu0, C1R2_B_E3_Q3_Cu0, C1R2_B_E3_Q2_Cu0, C1R2_B_E2_Q3_Cu0, C1R2_B_E2_Q2_Cu0, C1R2_B_E1_Q3_Cu0, C1R2_B_E1_Q2_Cu0, C1R1_F_SIG_B_Cu4, C1R1_F_SIG_B_Cu3, C1R1_F_SIG_B_Cu2, C1R1_F_SIG_B_Cu1, C1R1_F_SIG_B_Cu0, C1R1_F_SIG_A_Cu0, C1R1_B_SIG_B_Cu4, C1R1_B_SIG_B_Cu3, C1R1_B_SIG_B_Cu2, C1R1_B_SIG_B_Cu1, C1R1_B_SIG_B_Cu0, C1R1_B_SIG_A_Cu0, C1R1_B_RET_B_Cu0, C1R1_B_RET_A_Cu0, C1R1_B_E4_Q3_Cu0, C1R1_B_E4_Q2_Cu0, C1R1_B_E3_Q3_Cu0, C1R1_B_E3_Q2_Cu0, C1R1_B_E2_Q3_Cu0, C1R1_B_E2_Q2_Cu0, C1R1_B_E1_Q3_Cu0, C1R1_B_E1_Q2_Cu0 [Cobre_vol_Groiss] = imported_body(D:/dev/EMBRAER/P2M19/R04_72mm_ref146\cad\folha_cu.step)
  C1R1_A_ext = circle(normal=Z, centre=(-285.49083mm, -68mm, 14.769mm), radius=1.515mm)
  C1R1_A_int = circle(normal=Z, centre=(-285.49083mm, -68mm, 14.769mm), radius=0.525mm)
  C1R1_A_ext.subtract(C1R1_A_int)
  C1R1_B_ext = circle(normal=Z, centre=(-285.49083mm, -4mm, 14.769mm), radius=1.515mm)
  C1R1_B_int = circle(normal=Z, centre=(-285.49083mm, -4mm, 14.769mm), radius=0.525mm)
  C1R1_B_ext.subtract(C1R1_B_int)
  C1R2_A_ext = circle(normal=Z, centre=(-93.490832mm, -68mm, 14.769mm), radius=1.515mm)
  C1R2_A_int = circle(normal=Z, centre=(-93.490832mm, -68mm, 14.769mm), radius=0.525mm)
  C1R2_A_ext.subtract(C1R2_A_int)
  C1R2_B_ext = circle(normal=Z, centre=(-93.490832mm, -4mm, 14.769mm), radius=1.515mm)
  C1R2_B_int = circle(normal=Z, centre=(-93.490832mm, -4mm, 14.769mm), radius=0.525mm)
  C1R2_B_ext.subtract(C1R2_B_int)
  C1R3_A_ext = circle(normal=Z, centre=(98.509168mm, -68mm, 14.769mm), radius=1.515mm)
  C1R3_A_int = circle(normal=Z, centre=(98.509168mm, -68mm, 14.769mm), radius=0.525mm)
  C1R3_A_ext.subtract(C1R3_A_int)
  C1R3_B_ext = circle(normal=Z, centre=(98.509168mm, -4mm, 14.769mm), radius=1.515mm)
  C1R3_B_int = circle(normal=Z, centre=(98.509168mm, -4mm, 14.769mm), radius=0.525mm)
  C1R3_B_ext.subtract(C1R3_B_int)
  C1R4_A_ext = circle(normal=Z, centre=(290.50917mm, -68mm, 14.769mm), radius=1.515mm)
  C1R4_A_int = circle(normal=Z, centre=(290.50917mm, -68mm, 14.769mm), radius=0.525mm)
  C1R4_A_ext.subtract(C1R4_A_int)
  C1R4_B_ext = circle(normal=Z, centre=(290.50917mm, -4mm, 14.769mm), radius=1.515mm)
  C1R4_B_int = circle(normal=Z, centre=(290.50917mm, -4mm, 14.769mm), radius=0.525mm)
  C1R4_B_ext.subtract(C1R4_B_int)
  C2R1_A_ext = circle(normal=Z, centre=(-285.49083mm, 4mm, 14.769mm), radius=1.515mm)
  C2R1_A_int = circle(normal=Z, centre=(-285.49083mm, 4mm, 14.769mm), radius=0.525mm)
  C2R1_A_ext.subtract(C2R1_A_int)
  C2R1_B_ext = circle(normal=Z, centre=(-285.49083mm, 68mm, 14.769mm), radius=1.515mm)
  C2R1_B_int = circle(normal=Z, centre=(-285.49083mm, 68mm, 14.769mm), radius=0.525mm)
  C2R1_B_ext.subtract(C2R1_B_int)
  C2R2_A_ext = circle(normal=Z, centre=(-93.490832mm, 4mm, 14.769mm), radius=1.515mm)
  C2R2_A_int = circle(normal=Z, centre=(-93.490832mm, 4mm, 14.769mm), radius=0.525mm)
  C2R2_A_ext.subtract(C2R2_A_int)
  C2R2_B_ext = circle(normal=Z, centre=(-93.490832mm, 68mm, 14.769mm), radius=1.515mm)
  C2R2_B_int = circle(normal=Z, centre=(-93.490832mm, 68mm, 14.769mm), radius=0.525mm)
  C2R2_B_ext.subtract(C2R2_B_int)
  C2R3_A_ext = circle(normal=Z, centre=(98.509168mm, 4mm, 14.769mm), radius=1.515mm)
  C2R3_A_int = circle(normal=Z, centre=(98.509168mm, 4mm, 14.769mm), radius=0.525mm)
  C2R3_A_ext.subtract(C2R3_A_int)
  C2R3_B_ext = circle(normal=Z, centre=(98.509168mm, 68mm, 14.769mm), radius=1.515mm)
  C2R3_B_int = circle(normal=Z, centre=(98.509168mm, 68mm, 14.769mm), radius=0.525mm)
  C2R3_B_ext.subtract(C2R3_B_int)
  C2R4_A_ext = circle(normal=Z, centre=(290.50917mm, 4mm, 14.769mm), radius=1.515mm)
  C2R4_A_int = circle(normal=Z, centre=(290.50917mm, 4mm, 14.769mm), radius=0.525mm)
  C2R4_A_ext.subtract(C2R4_A_int)
  C2R4_B_ext = circle(normal=Z, centre=(290.50917mm, 68mm, 14.769mm), radius=1.515mm)
  C2R4_B_int = circle(normal=Z, centre=(290.50917mm, 68mm, 14.769mm), radius=0.525mm)
  C2R4_B_ext.subtract(C2R4_B_int)
  RadiatingSurface [vacuum] = region(absolute_offset=19.646365mm on all sides)
boundaries and excitations:
  ENIG_faces_expostas: Layered Impedance Faces=C1R1_B_E1_Q2_Cu0.face(at (-371.079, -33.407, 14.9315), at (-365.594, -35.7325, 14.9315), at (-373.404, -29.298, 14.9315), at (-361.351, -34.6488, 14.9315), at (-370.945, -25.0552, 14.9315), at (-360.268, -30.406, 14.9315), at (-366.702, -22.596, 14.9315), at (-362.593, -24.9214, 14.9315), at (-363.905, -25.3389, 14.9315), at (-362.459, -28.8386, 14.9315), at (-363.783, -32.2166, 14.9315), at (-367.161, -33.5408, 14.9315)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) C1R1_B_E1_Q3_Cu0.face(at (-366.625, -49.2491, 14.9315), at (-362.563, -46.9506, 14.9315), at (-370.818, -46.8183, 14.9315), at (-360.264, -41.5294, 14.9315), at (-373.249, -42.6246, 14.9315), at (-361.336, -37.3356, 14.9315), at (-370.951, -38.563, 14.9315), at (-365.529, -36.2644, 14.9315), at (-367.079, -38.4308, 14.9315), at (-363.74, -39.7397, 14.9315), at (-362.431, -43.0787, 14.9315), at (-363.86, -46.5379, 14.9315)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) C1R1_B_E2_Q2_Cu0.face(at (-323.079, -33.407, 14.9315), at (-317.594, -35.7325, 14.9315), at (-325.404, -29.298, 14.9315), at (-313.351, -34.6488, 14.9315), at (-322.945, -25.0552, 14.9315), at (-312.268, -30.406, 14.9315), at (-318.702, -22.596, 14.9315), at (-314.593, -24.9214, 14.9315), at (-315.905, -25.3389, 14.9315), at (-314.459, -28.8386, 14.9315), at (-315.783, -32.2166, 14.9315), at (-319.161, -33.5408, 14.9315)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) C1R1_B_E2_Q3_Cu0.face(at (-318.625, -49.2491, 14.9315), at (-314.563, -46.9506, 14.9315), at (-322.818, -46.8183, 14.9315), at (-312.264, -41.5294, 14.9315), at (-325.249, -42.6246, 14.9315), at (-313.336, -37.3356, 14.9315), at (-322.951, -38.563, 14.9315), at (-317.529, -36.2644, 14.9315), at (-319.079, -38.4308, 14.9315), at (-315.74, -39.7397, 14.9315), at (-314.431, -43.0787, 14.9315), at (-315.86, -46.5379, 14.9315)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) C1R1_B_E3_Q2_Cu0.face(at (-275.079, -33.407, 14.9315), at (-269.594, -35.7325, 14.9315), at (-277.404, -29.298, 14.9315), at (-265.351, -34.6488, 14.9315), at (-274.945, -25.0552, 14.9315), at (-264.268, -30.406, 14.9315), at (-270.702, -22.596, 14.9315), at (-266.593, -24.9214, 14.9315), at (-267.905, -25.3389, 14.9315), at (-266.459, -28.8386, 14.9315), at (-267.783, -32.2166, 14.9315), at (-271.161, -33.5408, 14.9315)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) C1R1_B_E3_Q3_Cu0.face(at (-270.625, -49.2491, 14.9315), at (-266.563, -46.9506, 14.9315), at (-274.818, -46.8183, 14.9315), at (-264.264, -41.5294, 14.9315), at (-277.249, -42.6246, 14.9315), at (-265.336, -37.3356, 14.9315), at (-274.951, -38.563, 14.9315), at (-269.529, -36.2644, 14.9315), at (-271.079, -38.4308, 14.9315), at (-267.74, -39.7397, 14.9315), at (-266.431, -43.0787, 14.9315), at (-267.86, -46.5379, 14.9315)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) C1R1_B_E4_Q2_Cu0.face(at (-227.079, -33.407, 14.9315), at (-221.594, -35.7325, 14.9315), at (-229.404, -29.298, 14.9315), at (-217.351, -34.6488, 14.9315), at (-226.945, -25.0552, 14.9315), at (-216.268, -30.406, 14.9315), at (-222.702, -22.596, 14.9315), at (-218.593, -24.9214, 14.9315), at (-219.905, -25.3389, 14.9315), at (-218.459, -28.8386, 14.9315), at (-219.783, -32.2166, 14.9315), at (-223.161, -33.5408, 14.9315)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) C1R1_B_E4_Q3_Cu0.face(at (-222.625, -49.2491, 14.9315), at (-218.563, -46.9506, 14.9315), at (-226.818, -46.8183, 14.9315), at (-216.264, -41.5294, 14.9315), at (-229.249, -42.6246, 14.9315), at (-217.336, -37.3356, 14.9315), at (-226.951, -38.563, 14.9315), at (-221.529, -36.2644, 14.9315), at (-223.079, -38.4308, 14.9315), at (-219.74, -39.7397, 14.9315), at (-218.431, -43.0787, 14.9315), at (-219.86, -46.5379, 14.9315)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) C1R1_B_RET_A_Cu0.face(at (-264.064, -41.5294, 14.9315), at (-264.066, -44.7364, 14.9315), at (-264.251, -38.1375, 14.9315), at (-264.068, -44.787, 14.9315), at (-264.435, -37.9375, 14.9315), at (-264.279, -45.0476, 14.9315), at (-264.397, -37.7811, 14.9315), at (-264.491, -51.1296, 14.9315), at (-264.312, -37.4997, 14.9315), at (-252.491, -57, 14.9315), at (-264.208, -37.2456, 14.9315), at (-240.491, -61, 14.9315)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) C1R1_B_RET_B_Cu0.face(at (-353.427, -35.7356, 14.9315), at (-349.049, -33.437, 14.9315), at (-355.547, -35.7727, 14.9315), at (-346.751, -29.3754, 14.9315), at (-355.648, -35.8549, 14.9315), at (-349.182, -25.1817, 14.9315), at (-357.316, -35.9, 14.9315), at (-353.052, -22.7509, 14.9315), at (-358.639, -35.6163, 14.9315), at (-354.491, -21.8754, 14.9315), at (-358.844, -34.8442, 14.9315), at (-333.491, -21, 14.9315)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) C1R1_B_SIG_A_Cu0.face(at (-284.693, -68.0523, 14.9315), at (-285.486, -68, 14.914), at (-284.693, -68.0523, 14.9315), at (-284.691, -68, 14.9315), at (-284.693, -67.9477, 14.9315), at (-284.704, -68.1432, 14.9315), at (-284.693, -67.9477, 14.9315), at (-284.704, -67.8568, 14.9315), at (-284.725, -68.2322, 14.9315), at (-284.725, -68.2322, 14.9315), at (-284.725, -67.7678, 14.9315), at (-284.729, -68.2447, 14.9315)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) C1R1_B_SIG_B_Cu0.face(at (-361.014, -37.0143, 14.9315), at (-359.653, -36.347, 14.9315), at (-360.347, -35.653, 14.9315), at (-360, -36, 14.914), at (-358.986, -34.9857, 14.9315), at (-360.947, -36.7474, 14.9315), at (-359.453, -35.2526, 14.9315)) C1R1_B_SIG_B_Cu1.face(at (-313.014, -37.0143, 14.9315), at (-311.653, -36.347, 14.9315), at (-312.347, -35.653, 14.9315), at (-312, -36, 14.914), at (-310.986, -34.9857, 14.9315), at (-312.947, -36.7474, 14.9315), at (-311.453, -35.2526, 14.9315)) C1R1_B_SIG_B_Cu2.face(at (-265.014, -37.0143, 14.9315), at (-263.653, -36.347, 14.9315), at (-264.347, -35.653, 14.9315), at (-264, -36, 14.914), at (-262.986, -34.9857, 14.9315), at (-264.947, -36.7474, 14.9315), at (-263.453, -35.2526, 14.9315)) C1R1_B_SIG_B_Cu3.face(at (-216.347, -35.653, 14.9315), at (-217.014, -37.0143, 14.9315), at (-214.986, -34.9857, 14.9315), at (-216, -36, 14.914), at (-215.653, -36.347, 14.9315), at (-216.947, -36.7474, 14.9315), at (-215.453, -35.2526, 14.9315)) C1R1_B_SIG_B_Cu4.face(at (-284.693, -4.05231, 14.9315), at (-285.486, -4, 14.914), at (-284.693, -4.05234, 14.9315), at (-284.691, -4, 14.9315), at (-284.693, -3.94769, 14.9315), at (-284.704, -4.14322, 14.9315), at (-284.693, -3.94766, 14.9315), at (-284.704, -3.85678, 14.9315), at (-284.725, -4.23222, 14.9315), at (-284.725, -4.23224, 14.9315), at (-284.725, -3.76778, 14.9315), at (-284.729, -4.24472, 14.9315)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) C1R1_F_SIG_A_Cu0.face(at (-272.021, -66.3543, 15.7265), at (-285.491, -65.6406, 15.7265), at (-265.724, -67.068, 15.7265), at (-289.426, -49.6656, 15.744), at (-298.961, -66.3543, 15.7265), at (-259.428, -66.284, 15.7265), at (-305.257, -67.068, 15.7265), at (-255.932, -65.5, 15.7265), at (-311.553, -66.284, 15.7265), at (-252.435, -66.3441, 15.7265), at (-315.05, -65.5, 15.7265), at (-245.369, -67.1883, 15.7265)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) C1R1_F_SIG_B_Cu0.face(at (-360.48, -36.4805, 15.7265), at (-361.602, -36.9076, 15.7265), at (-360.908, -37.6016, 15.7265), at (-363.63, -39.63, 15.744), at (-362.696, -37.3614, 15.7265), at (-361.361, -38.696, 15.7265), at (-365.093, -37.041, 15.7265), at (-361.041, -41.0926, 15.7265), at (-367.169, -37.5318, 15.7265), at (-361.532, -43.1688, 15.7265), at (-365.296, -38.0225, 15.7265), at (-362.023, -41.2959, 15.7265)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) C1R1_F_SIG_B_Cu1.face(at (-312.48, -36.4805, 15.7265), at (-313.602, -36.9076, 15.7265), at (-312.908, -37.6016, 15.7265), at (-315.63, -39.63, 15.744), at (-314.696, -37.3614, 15.7265), at (-313.361, -38.696, 15.7265), at (-317.093, -37.041, 15.7265), at (-313.041, -41.0926, 15.7265), at (-319.169, -37.5318, 15.7265), at (-313.532, -43.1688, 15.7265), at (-317.296, -38.0225, 15.7265), at (-314.023, -41.2959, 15.7265)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) C1R1_F_SIG_B_Cu2.face(at (-264.48, -36.4805, 15.7265), at (-265.602, -36.9076, 15.7265), at (-264.908, -37.6016, 15.7265), at (-267.63, -39.63, 15.744), at (-266.696, -37.3614, 15.7265), at (-265.361, -38.696, 15.7265), at (-269.093, -37.041, 15.7265), at (-265.041, -41.0926, 15.7265), at (-271.169, -37.5318, 15.7265), at (-265.532, -43.1688, 15.7265), at (-269.296, -38.0225, 15.7265), at (-266.023, -41.2959, 15.7265)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) C1R1_F_SIG_B_Cu3.face(at (-216.48, -36.4805, 15.7265), at (-217.602, -36.9076, 15.7265), at (-216.908, -37.6016, 15.7265), at (-219.63, -39.63, 15.744), at (-218.696, -37.3614, 15.7265), at (-217.361, -38.696, 15.7265), at (-221.093, -37.041, 15.7265), at (-217.041, -41.0926, 15.7265), at (-223.169, -37.5318, 15.7265), at (-217.532, -43.1688, 15.7265), at (-221.296, -38.0225, 15.7265), at (-218.023, -41.2959, 15.7265)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) C1R1_F_SIG_B_Cu4.face(at (-356.679, -33.8378, 15.7265), at (-356.645, -33.3386, 15.7265), at (-357.144, -34.3025, 15.7265), at (-286.238, -18.7864, 15.744), at (-356.645, -33.2694, 15.7265), at (-358.391, -35.0845, 15.7265), at (-356.679, -26.0233, 15.7265), at (-359.52, -35.5195, 15.7265), at (-349.087, -18.8117, 15.7265), at (-359.085, -34.3905, 15.7265), at (-341.495, -18.621, 15.7265), at (-358.303, -25.3984, 15.7265)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) C1R2_B_E1_Q2_Cu0.face(at (-179.079, -33.407, 14.9315), at (-173.594, -35.7325, 14.9315), at (-181.404, -29.298, 14.9315), at (-169.351, -34.6488, 14.9315), at (-178.945, -25.0552, 14.9315), at (-168.268, -30.406, 14.9315), at (-174.702, -22.596, 14.9315), at (-170.593, -24.9214, 14.9315), at (-171.905, -25.3389, 14.9315), at (-170.459, -28.8386, 14.9315), at (-171.783, -32.2166, 14.9315), at (-175.161, -33.5408, 14.9315)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) C1R2_B_E1_Q3_Cu0.face(at (-174.625, -49.2491, 14.9315), at (-170.563, -46.9506, 14.9315), at (-178.818, -46.8183, 14.9315), at (-168.264, -41.5294, 14.9315), at (-181.249, -42.6246, 14.9315), at (-169.336, -37.3356, 14.9315), at (-178.951, -38.563, 14.9315), at (-173.529, -36.2644, 14.9315), at (-175.079, -38.4308, 14.9315), at (-171.74, -39.7397, 14.9315), at (-170.431, -43.0787, 14.9315), at (-171.86, -46.5379, 14.9315)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) C1R2_B_E2_Q2_Cu0.face(at (-131.079, -33.407, 14.9315), at (-125.594, -35.7325, 14.9315), at (-133.404, -29.298, 14.9315), at (-121.351, -34.6488, 14.9315), at (-130.945, -25.0552, 14.9315), at (-120.268, -30.406, 14.9315), at (-126.702, -22.596, 14.9315), at (-122.593, -24.9214, 14.9315), at (-123.905, -25.3389, 14.9315), at (-122.459, -28.8386, 14.9315), at (-123.783, -32.2166, 14.9315), at (-127.161, -33.5408, 14.9315)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) C1R2_B_E2_Q3_Cu0.face(at (-126.625, -49.2491, 14.9315), at (-122.563, -46.9506, 14.9315), at (-130.818, -46.8183, 14.9315), at (-120.264, -41.5294, 14.9315), at (-133.249, -42.6246, 14.9315), at (-121.336, -37.3356, 14.9315), at (-130.951, -38.563, 14.9315), at (-125.529, -36.2644, 14.9315), at (-127.079, -38.4308, 14.9315), at (-123.74, -39.7397, 14.9315), at (-122.431, -43.0787, 14.9315), at (-123.86, -46.5379, 14.9315)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) C1R2_B_E3_Q2_Cu0.face(at (-83.0786, -33.407, 14.9315), at (-77.594, -35.7325, 14.9315), at (-85.404, -29.298, 14.9315), at (-73.3512, -34.6488, 14.9315), at (-82.9448, -25.0552, 14.9315), at (-72.2675, -30.406, 14.9315), at (-78.702, -22.596, 14.9315), at (-74.593, -24.9214, 14.9315), at (-75.905, -25.3389, 14.9315), at (-74.4592, -28.8386, 14.9315), at (-75.7834, -32.2166, 14.9315), at (-79.1614, -33.5408, 14.9315)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) C1R2_B_E3_Q3_Cu0.face(at (-78.6246, -49.2491, 14.9315), at (-74.563, -46.9506, 14.9315), at (-82.8183, -46.8183, 14.9315), at (-72.2644, -41.5294, 14.9315), at (-85.2491, -42.6246, 14.9315), at (-73.3356, -37.3356, 14.9315), at (-82.9506, -38.563, 14.9315), at (-77.5294, -36.2644, 14.9315), at (-79.0787, -38.4308, 14.9315), at (-75.7397, -39.7397, 14.9315), at (-74.4308, -43.0787, 14.9315), at (-75.8599, -46.5379, 14.9315)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) C1R2_B_E4_Q2_Cu0.face(at (-35.0786, -33.407, 14.9315), at (-29.594, -35.7325, 14.9315), at (-37.404, -29.298, 14.9315), at (-25.3512, -34.6488, 14.9315), at (-34.9448, -25.0552, 14.9315), at (-24.2675, -30.406, 14.9315), at (-30.702, -22.596, 14.9315), at (-26.593, -24.9214, 14.9315), at (-27.905, -25.3389, 14.9315), at (-26.4592, -28.8386, 14.9315), at (-27.7834, -32.2166, 14.9315), at (-31.1614, -33.5408, 14.9315)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) C1R2_B_E4_Q3_Cu0.face(at (-30.6246, -49.2491, 14.9315), at (-26.563, -46.9506, 14.9315), at (-34.8183, -46.8183, 14.9315), at (-24.2644, -41.5294, 14.9315), at (-37.2491, -42.6246, 14.9315), at (-25.3356, -37.3356, 14.9315), at (-34.9506, -38.563, 14.9315), at (-29.5294, -36.2644, 14.9315), at (-31.0787, -38.4308, 14.9315), at (-27.7397, -39.7397, 14.9315), at (-26.4308, -43.0787, 14.9315), at (-27.8599, -46.5379, 14.9315)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) C1R2_B_RET_A_Cu0.face(at (-72.0644, -41.5294, 14.9315), at (-72.066, -44.7364, 14.9315), at (-72.2508, -38.1375, 14.9315), at (-72.0675, -44.787, 14.9315), at (-72.4352, -37.9375, 14.9315), at (-72.2792, -45.0476, 14.9315), at (-72.3974, -37.7811, 14.9315), at (-72.4908, -51.1296, 14.9315), at (-72.3121, -37.4997, 14.9315), at (-60.4908, -57, 14.9315), at (-72.2078, -37.2456, 14.9315), at (-48.4908, -61, 14.9315)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) C1R2_B_RET_B_Cu0.face(at (-161.427, -35.7356, 14.9315), at (-157.049, -33.437, 14.9315), at (-163.547, -35.7727, 14.9315), at (-154.751, -29.3754, 14.9315), at (-163.648, -35.8549, 14.9315), at (-157.182, -25.1817, 14.9315), at (-165.316, -35.9, 14.9315), at (-161.052, -22.7509, 14.9315), at (-166.639, -35.6163, 14.9315), at (-162.491, -21.8754, 14.9315), at (-166.844, -34.8442, 14.9315), at (-141.491, -21, 14.9315)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) C1R2_B_SIG_A_Cu0.face(at (-92.6925, -68.0523, 14.9315), at (-93.486, -68, 14.914), at (-92.6925, -68.0523, 14.9315), at (-92.6908, -68, 14.9315), at (-92.6925, -67.9477, 14.9315), at (-92.7038, -68.1432, 14.9315), at (-92.6925, -67.9477, 14.9315), at (-92.7038, -67.8568, 14.9315), at (-92.7253, -68.2322, 14.9315), at (-92.7253, -68.2322, 14.9315), at (-92.7253, -67.7678, 14.9315), at (-92.7292, -68.2447, 14.9315)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) C1R2_B_SIG_B_Cu0.face(at (-169.014, -37.0143, 14.9315), at (-167.653, -36.347, 14.9315), at (-168.347, -35.653, 14.9315), at (-168, -36, 14.914), at (-166.986, -34.9857, 14.9315), at (-168.947, -36.7474, 14.9315), at (-167.453, -35.2526, 14.9315)) C1R2_B_SIG_B_Cu1.face(at (-121.014, -37.0143, 14.9315), at (-119.653, -36.347, 14.9315), at (-120.347, -35.653, 14.9315), at (-120, -36, 14.914), at (-118.986, -34.9857, 14.9315), at (-120.947, -36.7474, 14.9315), at (-119.453, -35.2526, 14.9315)) C1R2_B_SIG_B_Cu2.face(at (-73.0143, -37.0143, 14.9315), at (-71.653, -36.347, 14.9315), at (-72.347, -35.653, 14.9315), at (-72, -36, 14.914), at (-70.9857, -34.9857, 14.9315), at (-72.9474, -36.7474, 14.9315), at (-71.4526, -35.2526, 14.9315)) C1R2_B_SIG_B_Cu3.face(at (-24.347, -35.653, 14.9315), at (-25.0143, -37.0143, 14.9315), at (-22.9857, -34.9857, 14.9315), at (-24, -36, 14.914), at (-23.653, -36.347, 14.9315), at (-24.9474, -36.7474, 14.9315), at (-23.4526, -35.2526, 14.9315)) C1R2_B_SIG_B_Cu4.face(at (-92.6925, -4.05231, 14.9315), at (-93.486, -4, 14.914), at (-92.6925, -4.05234, 14.9315), at (-92.6908, -4, 14.9315), at (-92.6925, -3.94769, 14.9315), at (-92.7038, -4.14322, 14.9315), at (-92.6925, -3.94766, 14.9315), at (-92.7038, -3.85678, 14.9315), at (-92.7253, -4.23222, 14.9315), at (-92.7253, -4.23224, 14.9315), at (-92.7253, -3.76778, 14.9315), at (-92.7292, -4.24472, 14.9315)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) C1R2_F_SIG_A_Cu0.face(at (-80.0206, -66.3543, 15.7265), at (-93.4908, -65.6406, 15.7265), at (-73.7244, -67.068, 15.7265), at (-97.4257, -49.6656, 15.744), at (-106.961, -66.3543, 15.7265), at (-67.4283, -66.284, 15.7265), at (-113.257, -67.068, 15.7265), at (-63.9316, -65.5, 15.7265), at (-119.553, -66.284, 15.7265), at (-60.4348, -66.3441, 15.7265), at (-123.05, -65.5, 15.7265), at (-53.3687, -67.1883, 15.7265)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) C1R2_F_SIG_B_Cu0.face(at (-168.48, -36.4805, 15.7265), at (-169.602, -36.9076, 15.7265), at (-168.908, -37.6016, 15.7265), at (-171.63, -39.63, 15.744), at (-170.696, -37.3614, 15.7265), at (-169.361, -38.696, 15.7265), at (-173.093, -37.041, 15.7265), at (-169.041, -41.0926, 15.7265), at (-175.169, -37.5318, 15.7265), at (-169.532, -43.1688, 15.7265), at (-173.296, -38.0225, 15.7265), at (-170.023, -41.2959, 15.7265)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)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 Frequency=0GHz Layers{Layer1{Thickness=0.0254um Material=Ouro_vol_nominal} Layer2{Thickness=4.5um Material=NiP_vol_nominal} Layer3{LayerType=1 Thickness=0 Material=Cobre_vol_Groiss}}
  Open1: Radiation Objects=RadiatingSurface
  C1R1_A: Lumped Port Objects=C1R1_A_ext LumpedPortType=Modal Modes{Mode1{IntLine{(-284.96583, -68, 14.769) -> (-283.97583, -68, 14.769)} CharImp=Zpi RenormImp=50ohm}} Impedance=50ohm
  C1R1_B: Lumped Port Objects=C1R1_B_ext LumpedPortType=Modal Modes{Mode1{IntLine{(-284.96583, -4, 14.769) -> (-283.97583, -4, 14.769)} CharImp=Zpi RenormImp=50ohm}} Impedance=50ohm
  C1R2_A: Lumped Port Objects=C1R2_A_ext LumpedPortType=Modal Modes{Mode1{IntLine{(-92.965832, -68, 14.769) -> (-91.975832, -68, 14.769)} CharImp=Zpi RenormImp=50ohm}} Impedance=50ohm
  C1R2_B: Lumped Port Objects=C1R2_B_ext LumpedPortType=Modal Modes{Mode1{IntLine{(-92.965832, -4, 14.769) -> (-91.975832, -4, 14.769)} CharImp=Zpi RenormImp=50ohm}} Impedance=50ohm
  C1R3_A: Lumped Port Objects=C1R3_A_ext LumpedPortType=Modal Modes{Mode1{IntLine{(99.034168, -68, 14.769) -> (100.02417, -68, 14.769)} CharImp=Zpi RenormImp=50ohm}} Impedance=50ohm
  C1R3_B: Lumped Port Objects=C1R3_B_ext LumpedPortType=Modal Modes{Mode1{IntLine{(99.034168, -4, 14.769) -> (100.02417, -4, 14.769)} CharImp=Zpi RenormImp=50ohm}} Impedance=50ohm
  C1R4_A: Lumped Port Objects=C1R4_A_ext LumpedPortType=Modal Modes{Mode1{IntLine{(291.03417, -68, 14.769) -> (292.02417, -68, 14.769)} CharImp=Zpi RenormImp=50ohm}} Impedance=50ohm
  C1R4_B: Lumped Port Objects=C1R4_B_ext LumpedPortType=Modal Modes{Mode1{IntLine{(291.03417, -4, 14.769) -> (292.02417, -4, 14.769)} CharImp=Zpi RenormImp=50ohm}} Impedance=50ohm
  C2R1_A: Lumped Port Objects=C2R1_A_ext LumpedPortType=Modal Modes{Mode1{IntLine{(-284.96583, 4, 14.769) -> (-283.97583, 4, 14.769)} CharImp=Zpi RenormImp=50ohm}} Impedance=50ohm
  C2R1_B: Lumped Port Objects=C2R1_B_ext LumpedPortType=Modal Modes{Mode1{IntLine{(-284.96583, 68, 14.769) -> (-283.97583, 68, 14.769)} CharImp=Zpi RenormImp=50ohm}} Impedance=50ohm
  C2R2_A: Lumped Port Objects=C2R2_A_ext LumpedPortType=Modal Modes{Mode1{IntLine{(-92.965832, 4, 14.769) -> (-91.975832, 4, 14.769)} CharImp=Zpi RenormImp=50ohm}} Impedance=50ohm
  C2R2_B: Lumped Port Objects=C2R2_B_ext LumpedPortType=Modal Modes{Mode1{IntLine{(-92.965832, 68, 14.769) -> (-91.975832, 68, 14.769)} CharImp=Zpi RenormImp=50ohm}} Impedance=50ohm
  C2R3_A: Lumped Port Objects=C2R3_A_ext LumpedPortType=Modal Modes{Mode1{IntLine{(99.034168, 4, 14.769) -> (100.02417, 4, 14.769)} CharImp=Zpi RenormImp=50ohm}} Impedance=50ohm
  C2R3_B: Lumped Port Objects=C2R3_B_ext LumpedPortType=Modal Modes{Mode1{IntLine{(99.034168, 68, 14.769) -> (100.02417, 68, 14.769)} CharImp=Zpi RenormImp=50ohm}} Impedance=50ohm
  C2R4_A: Lumped Port Objects=C2R4_A_ext LumpedPortType=Modal Modes{Mode1{IntLine{(291.03417, 4, 14.769) -> (292.02417, 4, 14.769)} CharImp=Zpi RenormImp=50ohm}} Impedance=50ohm
  C2R4_B: Lumped Port Objects=C2R4_B_ext LumpedPortType=Modal Modes{Mode1{IntLine{(291.03417, 68, 14.769) -> (292.02417, 68, 14.769)} CharImp=Zpi RenormImp=50ohm}} Impedance=50ohm
mesh:
  initial mesh: GlobalCurvilinear{Apply} MeshMethod=AnsoftClassic
setups:
  Centro: HfssDriven Frequency=5.17GHz MaxDeltaS=0.05 MaximumPasses=12 MinimumPasses=12 MinimumConvergedPasses=2 PercentRefinement=20 BasisOrder=1 DoLambdaRefine=false PortAccuracy=2 DrivenSolverType="Direct Solver" SaveRadFieldsOnly ExpressionCache{CacheItem{Title=P2M19_Campo_00 Expression=dB(RealizedGainTotal) Intrinsics="Phi='90deg' Theta='0deg'" TraceID=145 ReportType=3} CacheItem{Title=P2M19_Campo_01 Expression=dB(RealizedGainTotal) Intrinsics="Phi='90deg' Theta='-10deg'" TraceID=146 ReportType=3} CacheItem{Title=P2M19_Campo_02 Expression=dB(RealizedGainTotal) Intrinsics="Phi='90deg' Theta='10deg'" TraceID=147 ReportType=3} CacheItem{Title=P2M19_Campo_03 Expression=dB(RealizedGainTotal) Intrinsics="Phi='90deg' Theta='-54deg'" TraceID=148 ReportType=3} CacheItem{Title=P2M19_Campo_04 Expression=dB(RealizedGainTotal) Intrinsics="Phi='90deg' Theta='54deg'" TraceID=149 ReportType=3} CacheItem{Title=P2M19_Campo_05 Expression=dB(RealizedGainTotal) Intrinsics="Phi='0deg' Theta='-1.75deg'" TraceID=150 ReportType=3} CacheItem{Title=P2M19_Campo_06 Expression=dB(RealizedGainTotal) Intrinsics="Phi='0deg' Theta='1.75deg'" TraceID=151 ReportType=3} CacheItem{Title=P2M19_Campo_07 Expression=dB(RealizedGainTotal) Intrinsics="Phi='0deg' Theta='-45deg'" TraceID=152 ReportType=3} CacheItem{Title=P2M19_Campo_08 Expression=dB(RealizedGainTotal) Intrinsics="Phi='0deg' Theta='45deg'" TraceID=153 ReportType=3}}
source amplitudes:
  C1R1_A:1, C1R1_B:1, C1R2_A:1, C1R2_B:1, C1R3_A:1, C1R3_B:1, C1R4_A:1, C1R4_B:1, C2R1_A:1, C2R1_B:1, C2R2_A:1, C2R2_B:1, C2R3_A:1, C2R3_B:1, C2R4_A:1, C2R4_B:1: 0.0625W 0deg
radiation setups:
  3D: Infinite Sphere Theta=0deg..180deg step 2deg Phi=-180deg..180deg step 2deg
  Elevation: Infinite Sphere Theta=-180deg..180deg step 1deg Phi=0deg..90deg step 90deg
  Azimuth: Infinite Sphere Theta=90deg..90deg step 0deg Phi=-180deg..180deg step 1deg
  HV: Infinite Sphere Theta=-180deg..180deg step 0.25deg Phi=0deg..90deg step 90deg
  Centro_fino: Infinite Sphere Theta=-20deg..20deg step 0.05deg Phi=0deg..90deg step 90deg
  Potencia: Infinite Sphere Theta=0deg..180deg step 2deg Phi=0deg..360deg step 2deg
reports:
  ALL_H: dB(RealizedGainTotal), dB(GainTotal), dB(DirTotal), re(rETheta), im(rETheta), re(rEPhi), im(rEPhi) vs Theta on Centro : LastAdaptive, HV [Phi=90deg Freq=5170MHz]
  ALL_V: dB(RealizedGainTotal), dB(GainTotal), dB(DirTotal), re(rETheta), im(rETheta), re(rEPhi), im(rEPhi) vs Theta on Centro : LastAdaptive, HV [Phi=0deg Freq=5170MHz]
  POL_A_H: dB(RealizedGainTotal), dB(GainTotal), dB(DirTotal), re(rETheta), im(rETheta), re(rEPhi), im(rEPhi) vs Theta on Centro : LastAdaptive, HV [Phi=90deg Freq=5170MHz]
  POL_A_V: dB(RealizedGainTotal), dB(GainTotal), dB(DirTotal), re(rETheta), im(rETheta), re(rEPhi), im(rEPhi) vs Theta on Centro : LastAdaptive, HV [Phi=0deg Freq=5170MHz]
  POL_B_H: dB(RealizedGainTotal), dB(GainTotal), dB(DirTotal), re(rETheta), im(rETheta), re(rEPhi), im(rEPhi) vs Theta on Centro : LastAdaptive, HV [Phi=90deg Freq=5170MHz]
  POL_B_V: dB(RealizedGainTotal), dB(GainTotal), dB(DirTotal), re(rETheta), im(rETheta), re(rEPhi), im(rEPhi) vs Theta on Centro : LastAdaptive, HV [Phi=0deg Freq=5170MHz]
  C1R1_A_H: dB(RealizedGainTotal), dB(GainTotal), dB(DirTotal), re(rETheta), im(rETheta), re(rEPhi), im(rEPhi) vs Theta on Centro : LastAdaptive, HV [Phi=90deg Freq=5170MHz]
  C1R1_A_V: dB(RealizedGainTotal), dB(GainTotal), dB(DirTotal), re(rETheta), im(rETheta), re(rEPhi), im(rEPhi) vs Theta on Centro : LastAdaptive, HV [Phi=0deg Freq=5170MHz]
  C1R1_B_H: dB(RealizedGainTotal), dB(GainTotal), dB(DirTotal), re(rETheta), im(rETheta), re(rEPhi), im(rEPhi) vs Theta on Centro : LastAdaptive, HV [Phi=90deg Freq=5170MHz]
  C1R1_B_V: dB(RealizedGainTotal), dB(GainTotal), dB(DirTotal), re(rETheta), im(rETheta), re(rEPhi), im(rEPhi) vs Theta on Centro : LastAdaptive, HV [Phi=0deg Freq=5170MHz]
  C1R2_A_H: dB(RealizedGainTotal), dB(GainTotal), dB(DirTotal), re(rETheta), im(rETheta), re(rEPhi), im(rEPhi) vs Theta on Centro : LastAdaptive, HV [Phi=90deg Freq=5170MHz]
  C1R2_A_V: dB(RealizedGainTotal), dB(GainTotal), dB(DirTotal), re(rETheta), im(rETheta), re(rEPhi), im(rEPhi) vs Theta on Centro : LastAdaptive, HV [Phi=0deg Freq=5170MHz]
  C1R2_B_H: dB(RealizedGainTotal), dB(GainTotal), dB(DirTotal), re(rETheta), im(rETheta), re(rEPhi), im(rEPhi) vs Theta on Centro : LastAdaptive, HV [Phi=90deg Freq=5170MHz]
  C1R2_B_V: dB(RealizedGainTotal), dB(GainTotal), dB(DirTotal), re(rETheta), im(rETheta), re(rEPhi), im(rEPhi) vs Theta on Centro : LastAdaptive, HV [Phi=0deg Freq=5170MHz]
  C1R3_A_H: dB(RealizedGainTotal), dB(GainTotal), dB(DirTotal), re(rETheta), im(rETheta), re(rEPhi), im(rEPhi) vs Theta on Centro : LastAdaptive, HV [Phi=90deg Freq=5170MHz]
  C1R3_A_V: dB(RealizedGainTotal), dB(GainTotal), dB(DirTotal), re(rETheta), im(rETheta), re(rEPhi), im(rEPhi) vs Theta on Centro : LastAdaptive, HV [Phi=0deg Freq=5170MHz]
  C1R3_B_H: dB(RealizedGainTotal), dB(GainTotal), dB(DirTotal), re(rETheta), im(rETheta), re(rEPhi), im(rEPhi) vs Theta on Centro : LastAdaptive, HV [Phi=90deg Freq=5170MHz]
  C1R3_B_V: dB(RealizedGainTotal), dB(GainTotal), dB(DirTotal), re(rETheta), im(rETheta), re(rEPhi), im(rEPhi) vs Theta on Centro : LastAdaptive, HV [Phi=0deg Freq=5170MHz]
  C1R4_A_H: dB(RealizedGainTotal), dB(GainTotal), dB(DirTotal), re(rETheta), im(rETheta), re(rEPhi), im(rEPhi) vs Theta on Centro : LastAdaptive, HV [Phi=90deg Freq=5170MHz]
  C1R4_A_V: dB(RealizedGainTotal), dB(GainTotal), dB(DirTotal), re(rETheta), im(rETheta), re(rEPhi), im(rEPhi) vs Theta on Centro : LastAdaptive, HV [Phi=0deg Freq=5170MHz]
  C1R4_B_H: dB(RealizedGainTotal), dB(GainTotal), dB(DirTotal), re(rETheta), im(rETheta), re(rEPhi), im(rEPhi) vs Theta on Centro : LastAdaptive, HV [Phi=90deg Freq=5170MHz]
  C1R4_B_V: dB(RealizedGainTotal), dB(GainTotal), dB(DirTotal), re(rETheta), im(rETheta), re(rEPhi), im(rEPhi) vs Theta on Centro : LastAdaptive, HV [Phi=0deg Freq=5170MHz]
  C2R1_A_H: dB(RealizedGainTotal), dB(GainTotal), dB(DirTotal), re(rETheta), im(rETheta), re(rEPhi), im(rEPhi) vs Theta on Centro : LastAdaptive, HV [Phi=90deg Freq=5170MHz]
  C2R1_A_V: dB(RealizedGainTotal), dB(GainTotal), dB(DirTotal), re(rETheta), im(rETheta), re(rEPhi), im(rEPhi) vs Theta on Centro : LastAdaptive, HV [Phi=0deg Freq=5170MHz]
  C2R1_B_H: dB(RealizedGainTotal), dB(GainTotal), dB(DirTotal), re(rETheta), im(rETheta), re(rEPhi), im(rEPhi) vs Theta on Centro : LastAdaptive, HV [Phi=90deg Freq=5170MHz]
  C2R1_B_V: dB(RealizedGainTotal), dB(GainTotal), dB(DirTotal), re(rETheta), im(rETheta), re(rEPhi), im(rEPhi) vs Theta on Centro : LastAdaptive, HV [Phi=0deg Freq=5170MHz]
  C2R2_A_H: dB(RealizedGainTotal), dB(GainTotal), dB(DirTotal), re(rETheta), im(rETheta), re(rEPhi), im(rEPhi) vs Theta on Centro : LastAdaptive, HV [Phi=90deg Freq=5170MHz]
  C2R2_A_V: dB(RealizedGainTotal), dB(GainTotal), dB(DirTotal), re(rETheta), im(rETheta), re(rEPhi), im(rEPhi) vs Theta on Centro : LastAdaptive, HV [Phi=0deg Freq=5170MHz]
  C2R2_B_H: dB(RealizedGainTotal), dB(GainTotal), dB(DirTotal), re(rETheta), im(rETheta), re(rEPhi), im(rEPhi) vs Theta on Centro : LastAdaptive, HV [Phi=90deg Freq=5170MHz]
  C2R2_B_V: dB(RealizedGainTotal), dB(GainTotal), dB(DirTotal), re(rETheta), im(rETheta), re(rEPhi), im(rEPhi) vs Theta on Centro : LastAdaptive, HV [Phi=0deg Freq=5170MHz]
  C2R3_A_H: dB(RealizedGainTotal), dB(GainTotal), dB(DirTotal), re(rETheta), im(rETheta), re(rEPhi), im(rEPhi) vs Theta on Centro : LastAdaptive, HV [Phi=90deg Freq=5170MHz]
  C2R3_A_V: dB(RealizedGainTotal), dB(GainTotal), dB(DirTotal), re(rETheta), im(rETheta), re(rEPhi), im(rEPhi) vs Theta on Centro : LastAdaptive, HV [Phi=0deg Freq=5170MHz]
  C2R3_B_H: dB(RealizedGainTotal), dB(GainTotal), dB(DirTotal), re(rETheta), im(rETheta), re(rEPhi), im(rEPhi) vs Theta on Centro : LastAdaptive, HV [Phi=90deg Freq=5170MHz]
  C2R3_B_V: dB(RealizedGainTotal), dB(GainTotal), dB(DirTotal), re(rETheta), im(rETheta), re(rEPhi), im(rEPhi) vs Theta on Centro : LastAdaptive, HV [Phi=0deg Freq=5170MHz]
  C2R4_A_H: dB(RealizedGainTotal), dB(GainTotal), dB(DirTotal), re(rETheta), im(rETheta), re(rEPhi), im(rEPhi) vs Theta on Centro : LastAdaptive, HV [Phi=90deg Freq=5170MHz]
  C2R4_A_V: dB(RealizedGainTotal), dB(GainTotal), dB(DirTotal), re(rETheta), im(rETheta), re(rEPhi), im(rEPhi) vs Theta on Centro : LastAdaptive, HV [Phi=0deg Freq=5170MHz]
  C2R4_B_H: dB(RealizedGainTotal), dB(GainTotal), dB(DirTotal), re(rETheta), im(rETheta), re(rEPhi), im(rEPhi) vs Theta on Centro : LastAdaptive, HV [Phi=90deg Freq=5170MHz]
  C2R4_B_V: dB(RealizedGainTotal), dB(GainTotal), dB(DirTotal), re(rETheta), im(rETheta), re(rEPhi), im(rEPhi) vs Theta on Centro : LastAdaptive, HV [Phi=0deg Freq=5170MHz]
  ALL_H_fino: dB(RealizedGainTotal), re(rETheta), im(rETheta), re(rEPhi), im(rEPhi) vs Theta on Centro : LastAdaptive, Centro_fino [Phi=90deg Freq=5170MHz]
  ALL_V_fino: dB(RealizedGainTotal), re(rETheta), im(rETheta), re(rEPhi), im(rEPhi) vs Theta on Centro : LastAdaptive, Centro_fino [Phi=0deg Freq=5170MHz]
  ALL_Potencia: dB(RealizedGainTotal) vs Theta on Centro : LastAdaptive, Potencia [Phi=all Freq=5170MHz]
