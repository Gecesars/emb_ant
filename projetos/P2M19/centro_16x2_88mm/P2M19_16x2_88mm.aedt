# Ansys Electronics Desktop project, version 2024.2
materials:
  vacuum: permittivity=1
  POM_nom: permittivity=3.4 dielectric_loss_tangent=0.01
  PTFE_terminal: permittivity=2.0363635 dielectric_loss_tangent=0.00027683055
  ZYF300: permittivity=2.94 dielectric_loss_tangent=0.0016
  RO4350B_R01: permittivity=3.66 dielectric_loss_tangent=0.0037
  AL5052: conductivity=20000000
  SAC305: conductivity=7575758
  copper: permeability=0.999991 conductivity=58000000
  NiP_vol_nominal: permeability=1 conductivity=1500000
  Ouro_vol_nominal: permeability=1 conductivity=41000000
  Cobre_vol_Groiss: permeability=1 conductivity=28688604

design P2M19_16x2 (HFSS, HFSS Hybrid Modal Network, model units mm)
geometry:
  Refletor_Al2mm [AL5052] = imported_body(D:/dev/EMBRAER/P2M19/R01_16x2_88mm\cad\AL5052.step)
  C2R4_PTFE_B, C2R4_PTFE_A, C2R3_PTFE_B, C2R3_PTFE_A, C2R2_PTFE_B, C2R2_PTFE_A, C2R1_PTFE_B, C2R1_PTFE_A, C1R4_PTFE_B, C1R4_PTFE_A, C1R3_PTFE_B, C1R3_PTFE_A, C1R2_PTFE_B, C1R2_PTFE_A, C1R1_PTFE_B, C1R1_PTFE_A [PTFE_terminal] = imported_body(D:/dev/EMBRAER/P2M19/R01_16x2_88mm\cad\PTFE_terminal.step)
  C2R4_PCB_RO4350B, C2R3_PCB_RO4350B, C2R2_PCB_RO4350B, C2R1_PCB_RO4350B, C1R4_PCB_RO4350B, C1R3_PCB_RO4350B, C1R2_PCB_RO4350B, C1R1_PCB_RO4350B [RO4350B_R01] = imported_body(D:/dev/EMBRAER/P2M19/R01_16x2_88mm\cad\RO4350B_R01.step)
  C2R4_Solda_B, C2R4_Solda_A, C2R3_Solda_B, C2R3_Solda_A, C2R2_Solda_B, C2R2_Solda_A, C2R1_Solda_B, C2R1_Solda_A, C1R4_Solda_B, C1R4_Solda_A, C1R3_Solda_B, C1R3_Solda_A, C1R2_Solda_B, C1R2_Solda_A, C1R1_Solda_B, C1R1_Solda_A [SAC305] = imported_body(D:/dev/EMBRAER/P2M19/R01_16x2_88mm\cad\SAC305.step)
  C2R4_PTH_B, C2R4_Blindagem_B, C2R4_Vivo_B, C2R4_PTH_A, C2R4_Blindagem_A, C2R4_Vivo_A, C2R4_Via_7, C2R4_Via_6, C2R4_Via_5, C2R4_Via_4, C2R4_Via_3, C2R4_Via_2, C2R4_Via_1, C2R4_Via_0, C2R3_PTH_B, C2R3_Blindagem_B, C2R3_Vivo_B, C2R3_PTH_A, C2R3_Blindagem_A, C2R3_Vivo_A, C2R3_Via_7, C2R3_Via_6, C2R3_Via_5, C2R3_Via_4, C2R3_Via_3, C2R3_Via_2, C2R3_Via_1, C2R3_Via_0, C2R2_PTH_B, C2R2_Blindagem_B, C2R2_Vivo_B, C2R2_PTH_A, C2R2_Blindagem_A, C2R2_Vivo_A, C2R2_Via_7, C2R2_Via_6, C2R2_Via_5, C2R2_Via_4, C2R2_Via_3, C2R2_Via_2, C2R2_Via_1, C2R2_Via_0, C2R1_PTH_B, C2R1_Blindagem_B, C2R1_Vivo_B, C2R1_PTH_A, C2R1_Blindagem_A, C2R1_Vivo_A, C2R1_Via_7, C2R1_Via_6, C2R1_Via_5, C2R1_Via_4, C2R1_Via_3, C2R1_Via_2, C2R1_Via_1, C2R1_Via_0, C1R4_PTH_B, C1R4_Blindagem_B, C1R4_Vivo_B, C1R4_PTH_A, C1R4_Blindagem_A, C1R4_Vivo_A, C1R4_Via_7, C1R4_Via_6, C1R4_Via_5, C1R4_Via_4, C1R4_Via_3, C1R4_Via_2, C1R4_Via_1, C1R4_Via_0, C1R3_PTH_B, C1R3_Blindagem_B, C1R3_Vivo_B, C1R3_PTH_A, C1R3_Blindagem_A, C1R3_Vivo_A, C1R3_Via_7, C1R3_Via_6, C1R3_Via_5, C1R3_Via_4, C1R3_Via_3, C1R3_Via_2, C1R3_Via_1, C1R3_Via_0, C1R2_PTH_B, C1R2_Blindagem_B, C1R2_Vivo_B, C1R2_PTH_A, C1R2_Blindagem_A, C1R2_Vivo_A, C1R2_Via_7, C1R2_Via_6, C1R2_Via_5, C1R2_Via_4, C1R2_Via_3, C1R2_Via_2, C1R2_Via_1, C1R2_Via_0, C1R1_PTH_B, C1R1_Blindagem_B, C1R1_Vivo_B, C1R1_PTH_A, C1R1_Blindagem_A, C1R1_Vivo_A, C1R1_Via_7, C1R1_Via_6, C1R1_Via_5, C1R1_Via_4, C1R1_Via_3, C1R1_Via_2, C1R1_Via_1, C1R1_Via_0 [copper] = imported_body(D:/dev/EMBRAER/P2M19/R01_16x2_88mm\cad\copper.step)
  C2R4_F_SIG_B_Cu4, C2R4_F_SIG_B_Cu3, C2R4_F_SIG_B_Cu2, C2R4_F_SIG_B_Cu1, C2R4_F_SIG_B_Cu0, C2R4_F_SIG_A_Cu0, C2R4_B_SIG_B_Cu4, C2R4_B_SIG_B_Cu3, C2R4_B_SIG_B_Cu2, C2R4_B_SIG_B_Cu1, C2R4_B_SIG_B_Cu0, C2R4_B_SIG_A_Cu0, C2R4_B_RET_B_Cu0, C2R4_B_RET_A_Cu0, C2R4_B_E4_Q3_Cu0, C2R4_B_E4_Q2_Cu0, C2R4_B_E3_Q3_Cu0, C2R4_B_E3_Q2_Cu0, C2R4_B_E2_Q3_Cu0, C2R4_B_E2_Q2_Cu0, C2R4_B_E1_Q3_Cu0, C2R4_B_E1_Q2_Cu0, C2R3_F_SIG_B_Cu4, C2R3_F_SIG_B_Cu3, C2R3_F_SIG_B_Cu2, C2R3_F_SIG_B_Cu1, C2R3_F_SIG_B_Cu0, C2R3_F_SIG_A_Cu0, C2R3_B_SIG_B_Cu4, C2R3_B_SIG_B_Cu3, C2R3_B_SIG_B_Cu2, C2R3_B_SIG_B_Cu1, C2R3_B_SIG_B_Cu0, C2R3_B_SIG_A_Cu0, C2R3_B_RET_B_Cu0, C2R3_B_RET_A_Cu0, C2R3_B_E4_Q3_Cu0, C2R3_B_E4_Q2_Cu0, C2R3_B_E3_Q3_Cu0, C2R3_B_E3_Q2_Cu0, C2R3_B_E2_Q3_Cu0, C2R3_B_E2_Q2_Cu0, C2R3_B_E1_Q3_Cu0, C2R3_B_E1_Q2_Cu0, C2R2_F_SIG_B_Cu4, C2R2_F_SIG_B_Cu3, C2R2_F_SIG_B_Cu2, C2R2_F_SIG_B_Cu1, C2R2_F_SIG_B_Cu0, C2R2_F_SIG_A_Cu0, C2R2_B_SIG_B_Cu4, C2R2_B_SIG_B_Cu3, C2R2_B_SIG_B_Cu2, C2R2_B_SIG_B_Cu1, C2R2_B_SIG_B_Cu0, C2R2_B_SIG_A_Cu0, C2R2_B_RET_B_Cu0, C2R2_B_RET_A_Cu0, C2R2_B_E4_Q3_Cu0, C2R2_B_E4_Q2_Cu0, C2R2_B_E3_Q3_Cu0, C2R2_B_E3_Q2_Cu0, C2R2_B_E2_Q3_Cu0, C2R2_B_E2_Q2_Cu0, C2R2_B_E1_Q3_Cu0, C2R2_B_E1_Q2_Cu0, C2R1_F_SIG_B_Cu4, C2R1_F_SIG_B_Cu3, C2R1_F_SIG_B_Cu2, C2R1_F_SIG_B_Cu1, C2R1_F_SIG_B_Cu0, C2R1_F_SIG_A_Cu0, C2R1_B_SIG_B_Cu4, C2R1_B_SIG_B_Cu3, C2R1_B_SIG_B_Cu2, C2R1_B_SIG_B_Cu1, C2R1_B_SIG_B_Cu0, C2R1_B_SIG_A_Cu0, C2R1_B_RET_B_Cu0, C2R1_B_RET_A_Cu0, C2R1_B_E4_Q3_Cu0, C2R1_B_E4_Q2_Cu0, C2R1_B_E3_Q3_Cu0, C2R1_B_E3_Q2_Cu0, C2R1_B_E2_Q3_Cu0, C2R1_B_E2_Q2_Cu0, C2R1_B_E1_Q3_Cu0, C2R1_B_E1_Q2_Cu0, C1R4_F_SIG_B_Cu4, C1R4_F_SIG_B_Cu3, C1R4_F_SIG_B_Cu2, C1R4_F_SIG_B_Cu1, C1R4_F_SIG_B_Cu0, C1R4_F_SIG_A_Cu0, C1R4_B_SIG_B_Cu4, C1R4_B_SIG_B_Cu3, C1R4_B_SIG_B_Cu2, C1R4_B_SIG_B_Cu1, C1R4_B_SIG_B_Cu0, C1R4_B_SIG_A_Cu0, C1R4_B_RET_B_Cu0, C1R4_B_RET_A_Cu0, C1R4_B_E4_Q3_Cu0, C1R4_B_E4_Q2_Cu0, C1R4_B_E3_Q3_Cu0, C1R4_B_E3_Q2_Cu0, C1R4_B_E2_Q3_Cu0, C1R4_B_E2_Q2_Cu0, C1R4_B_E1_Q3_Cu0, C1R4_B_E1_Q2_Cu0, C1R3_F_SIG_B_Cu4, C1R3_F_SIG_B_Cu3, C1R3_F_SIG_B_Cu2, C1R3_F_SIG_B_Cu1, C1R3_F_SIG_B_Cu0, C1R3_F_SIG_A_Cu0, C1R3_B_SIG_B_Cu4, C1R3_B_SIG_B_Cu3, C1R3_B_SIG_B_Cu2, C1R3_B_SIG_B_Cu1, C1R3_B_SIG_B_Cu0, C1R3_B_SIG_A_Cu0, C1R3_B_RET_B_Cu0, C1R3_B_RET_A_Cu0, C1R3_B_E4_Q3_Cu0, C1R3_B_E4_Q2_Cu0, C1R3_B_E3_Q3_Cu0, C1R3_B_E3_Q2_Cu0, C1R3_B_E2_Q3_Cu0, C1R3_B_E2_Q2_Cu0, C1R3_B_E1_Q3_Cu0, C1R3_B_E1_Q2_Cu0, C1R2_F_SIG_B_Cu4, C1R2_F_SIG_B_Cu3, C1R2_F_SIG_B_Cu2, C1R2_F_SIG_B_Cu1, C1R2_F_SIG_B_Cu0, C1R2_F_SIG_A_Cu0, C1R2_B_SIG_B_Cu4, C1R2_B_SIG_B_Cu3, C1R2_B_SIG_B_Cu2, C1R2_B_SIG_B_Cu1, C1R2_B_SIG_B_Cu0, C1R2_B_SIG_A_Cu0, C1R2_B_RET_B_Cu0, C1R2_B_RET_A_Cu0, C1R2_B_E4_Q3_Cu0, C1R2_B_E4_Q2_Cu0, C1R2_B_E3_Q3_Cu0, C1R2_B_E3_Q2_Cu0, C1R2_B_E2_Q3_Cu0, C1R2_B_E2_Q2_Cu0, C1R2_B_E1_Q3_Cu0, C1R2_B_E1_Q2_Cu0, C1R1_F_SIG_B_Cu4, C1R1_F_SIG_B_Cu3, C1R1_F_SIG_B_Cu2, C1R1_F_SIG_B_Cu1, C1R1_F_SIG_B_Cu0, C1R1_F_SIG_A_Cu0, C1R1_B_SIG_B_Cu4, C1R1_B_SIG_B_Cu3, C1R1_B_SIG_B_Cu2, C1R1_B_SIG_B_Cu1, C1R1_B_SIG_B_Cu0, C1R1_B_SIG_A_Cu0, C1R1_B_RET_B_Cu0, C1R1_B_RET_A_Cu0, C1R1_B_E4_Q3_Cu0, C1R1_B_E4_Q2_Cu0, C1R1_B_E3_Q3_Cu0, C1R1_B_E3_Q2_Cu0, C1R1_B_E2_Q3_Cu0, C1R1_B_E2_Q2_Cu0, C1R1_B_E1_Q3_Cu0, C1R1_B_E1_Q2_Cu0 [Cobre_vol_Groiss] = imported_body(D:/dev/EMBRAER/P2M19/R01_16x2_88mm\cad\folha_cu.step)
  C1R1_A_ext = circle(normal=Z, centre=(-285.49083mm, -76mm, 14.769mm), radius=1.515mm)
  C1R1_A_int = circle(normal=Z, centre=(-285.49083mm, -76mm, 14.769mm), radius=0.525mm)
  C1R1_A_ext.subtract(C1R1_A_int)
  C1R1_B_ext = circle(normal=Z, centre=(-285.49083mm, -12mm, 14.769mm), radius=1.515mm)
  C1R1_B_int = circle(normal=Z, centre=(-285.49083mm, -12mm, 14.769mm), radius=0.525mm)
  C1R1_B_ext.subtract(C1R1_B_int)
  C1R2_A_ext = circle(normal=Z, centre=(-93.490832mm, -76mm, 14.769mm), radius=1.515mm)
  C1R2_A_int = circle(normal=Z, centre=(-93.490832mm, -76mm, 14.769mm), radius=0.525mm)
  C1R2_A_ext.subtract(C1R2_A_int)
  C1R2_B_ext = circle(normal=Z, centre=(-93.490832mm, -12mm, 14.769mm), radius=1.515mm)
  C1R2_B_int = circle(normal=Z, centre=(-93.490832mm, -12mm, 14.769mm), radius=0.525mm)
  C1R2_B_ext.subtract(C1R2_B_int)
  C1R3_A_ext = circle(normal=Z, centre=(98.509168mm, -76mm, 14.769mm), radius=1.515mm)
  C1R3_A_int = circle(normal=Z, centre=(98.509168mm, -76mm, 14.769mm), radius=0.525mm)
  C1R3_A_ext.subtract(C1R3_A_int)
  C1R3_B_ext = circle(normal=Z, centre=(98.509168mm, -12mm, 14.769mm), radius=1.515mm)
  C1R3_B_int = circle(normal=Z, centre=(98.509168mm, -12mm, 14.769mm), radius=0.525mm)
  C1R3_B_ext.subtract(C1R3_B_int)
  C1R4_A_ext = circle(normal=Z, centre=(290.50917mm, -76mm, 14.769mm), radius=1.515mm)
  C1R4_A_int = circle(normal=Z, centre=(290.50917mm, -76mm, 14.769mm), radius=0.525mm)
  C1R4_A_ext.subtract(C1R4_A_int)
  C1R4_B_ext = circle(normal=Z, centre=(290.50917mm, -12mm, 14.769mm), radius=1.515mm)
  C1R4_B_int = circle(normal=Z, centre=(290.50917mm, -12mm, 14.769mm), radius=0.525mm)
  C1R4_B_ext.subtract(C1R4_B_int)
  C2R1_A_ext = circle(normal=Z, centre=(-285.49083mm, 12mm, 14.769mm), radius=1.515mm)
  C2R1_A_int = circle(normal=Z, centre=(-285.49083mm, 12mm, 14.769mm), radius=0.525mm)
  C2R1_A_ext.subtract(C2R1_A_int)
  C2R1_B_ext = circle(normal=Z, centre=(-285.49083mm, 76mm, 14.769mm), radius=1.515mm)
  C2R1_B_int = circle(normal=Z, centre=(-285.49083mm, 76mm, 14.769mm), radius=0.525mm)
  C2R1_B_ext.subtract(C2R1_B_int)
  C2R2_A_ext = circle(normal=Z, centre=(-93.490832mm, 12mm, 14.769mm), radius=1.515mm)
  C2R2_A_int = circle(normal=Z, centre=(-93.490832mm, 12mm, 14.769mm), radius=0.525mm)
  C2R2_A_ext.subtract(C2R2_A_int)
  C2R2_B_ext = circle(normal=Z, centre=(-93.490832mm, 76mm, 14.769mm), radius=1.515mm)
  C2R2_B_int = circle(normal=Z, centre=(-93.490832mm, 76mm, 14.769mm), radius=0.525mm)
  C2R2_B_ext.subtract(C2R2_B_int)
  C2R3_A_ext = circle(normal=Z, centre=(98.509168mm, 12mm, 14.769mm), radius=1.515mm)
  C2R3_A_int = circle(normal=Z, centre=(98.509168mm, 12mm, 14.769mm), radius=0.525mm)
  C2R3_A_ext.subtract(C2R3_A_int)
  C2R3_B_ext = circle(normal=Z, centre=(98.509168mm, 76mm, 14.769mm), radius=1.515mm)
  C2R3_B_int = circle(normal=Z, centre=(98.509168mm, 76mm, 14.769mm), radius=0.525mm)
  C2R3_B_ext.subtract(C2R3_B_int)
  C2R4_A_ext = circle(normal=Z, centre=(290.50917mm, 12mm, 14.769mm), radius=1.515mm)
  C2R4_A_int = circle(normal=Z, centre=(290.50917mm, 12mm, 14.769mm), radius=0.525mm)
  C2R4_A_ext.subtract(C2R4_A_int)
  C2R4_B_ext = circle(normal=Z, centre=(290.50917mm, 76mm, 14.769mm), radius=1.515mm)
  C2R4_B_int = circle(normal=Z, centre=(290.50917mm, 76mm, 14.769mm), radius=0.525mm)
  C2R4_B_ext.subtract(C2R4_B_int)
  RadiatingSurface [vacuum] = region(absolute_offset=19.646365mm on all sides)
boundaries and excitations:
  ENIG_faces_expostas: Layered Impedance Faces=C1R1_B_E1_Q2_Cu0.face(at (-371.079, -41.407, 14.9315), at (-365.594, -43.7325, 14.9315), at (-373.404, -37.298, 14.9315), at (-361.351, -42.6488, 14.9315), at (-370.945, -33.0552, 14.9315), at (-360.268, -38.406, 14.9315), at (-366.702, -30.596, 14.9315), at (-362.593, -32.9214, 14.9315), at (-363.905, -33.3389, 14.9315), at (-362.459, -36.8386, 14.9315), at (-363.783, -40.2166, 14.9315), at (-367.161, -41.5408, 14.9315)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) C1R1_B_E1_Q3_Cu0.face(at (-366.625, -57.2491, 14.9315), at (-362.563, -54.9506, 14.9315), at (-370.818, -54.8183, 14.9315), at (-360.264, -49.5294, 14.9315), at (-373.249, -50.6246, 14.9315), at (-361.336, -45.3356, 14.9315), at (-370.951, -46.563, 14.9315), at (-365.529, -44.2644, 14.9315), at (-367.079, -46.4308, 14.9315), at (-363.74, -47.7397, 14.9315), at (-362.431, -51.0787, 14.9315), at (-363.86, -54.5379, 14.9315)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) C1R1_B_E2_Q2_Cu0.face(at (-323.079, -41.407, 14.9315), at (-317.594, -43.7325, 14.9315), at (-325.404, -37.298, 14.9315), at (-313.351, -42.6488, 14.9315), at (-322.945, -33.0552, 14.9315), at (-312.268, -38.406, 14.9315), at (-318.702, -30.596, 14.9315), at (-314.593, -32.9214, 14.9315), at (-315.905, -33.3389, 14.9315), at (-314.459, -36.8386, 14.9315), at (-315.783, -40.2166, 14.9315), at (-319.161, -41.5408, 14.9315)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) C1R1_B_E2_Q3_Cu0.face(at (-318.625, -57.2491, 14.9315), at (-314.563, -54.9506, 14.9315), at (-322.818, -54.8183, 14.9315), at (-312.264, -49.5294, 14.9315), at (-325.249, -50.6246, 14.9315), at (-313.336, -45.3356, 14.9315), at (-322.951, -46.563, 14.9315), at (-317.529, -44.2644, 14.9315), at (-319.079, -46.4308, 14.9315), at (-315.74, -47.7397, 14.9315), at (-314.431, -51.0787, 14.9315), at (-315.86, -54.5379, 14.9315)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) C1R1_B_E3_Q2_Cu0.face(at (-275.079, -41.407, 14.9315), at (-269.594, -43.7325, 14.9315), at (-277.404, -37.298, 14.9315), at (-265.351, -42.6488, 14.9315), at (-274.945, -33.0552, 14.9315), at (-264.268, -38.406, 14.9315), at (-270.702, -30.596, 14.9315), at (-266.593, -32.9214, 14.9315), at (-267.905, -33.3389, 14.9315), at (-266.459, -36.8386, 14.9315), at (-267.783, -40.2166, 14.9315), at (-271.161, -41.5408, 14.9315)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) C1R1_B_E3_Q3_Cu0.face(at (-270.625, -57.2491, 14.9315), at (-266.563, -54.9506, 14.9315), at (-274.818, -54.8183, 14.9315), at (-264.264, -49.5294, 14.9315), at (-277.249, -50.6246, 14.9315), at (-265.336, -45.3356, 14.9315), at (-274.951, -46.563, 14.9315), at (-269.529, -44.2644, 14.9315), at (-271.079, -46.4308, 14.9315), at (-267.74, -47.7397, 14.9315), at (-266.431, -51.0787, 14.9315), at (-267.86, -54.5379, 14.9315)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) C1R1_B_E4_Q2_Cu0.face(at (-227.079, -41.407, 14.9315), at (-221.594, -43.7325, 14.9315), at (-229.404, -37.298, 14.9315), at (-217.351, -42.6488, 14.9315), at (-226.945, -33.0552, 14.9315), at (-216.268, -38.406, 14.9315), at (-222.702, -30.596, 14.9315), at (-218.593, -32.9214, 14.9315), at (-219.905, -33.3389, 14.9315), at (-218.459, -36.8386, 14.9315), at (-219.783, -40.2166, 14.9315), at (-223.161, -41.5408, 14.9315)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) C1R1_B_E4_Q3_Cu0.face(at (-222.625, -57.2491, 14.9315), at (-218.563, -54.9506, 14.9315), at (-226.818, -54.8183, 14.9315), at (-216.264, -49.5294, 14.9315), at (-229.249, -50.6246, 14.9315), at (-217.336, -45.3356, 14.9315), at (-226.951, -46.563, 14.9315), at (-221.529, -44.2644, 14.9315), at (-223.079, -46.4308, 14.9315), at (-219.74, -47.7397, 14.9315), at (-218.431, -51.0787, 14.9315), at (-219.86, -54.5379, 14.9315)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) C1R1_B_RET_A_Cu0.face(at (-264.064, -49.5294, 14.9315), at (-264.066, -52.7364, 14.9315), at (-264.251, -46.1375, 14.9315), at (-264.068, -52.787, 14.9315), at (-264.435, -45.9375, 14.9315), at (-264.279, -53.0476, 14.9315), at (-264.397, -45.7811, 14.9315), at (-264.491, -59.1296, 14.9315), at (-264.312, -45.4997, 14.9315), at (-252.491, -65, 14.9315), at (-264.208, -45.2456, 14.9315), at (-240.491, -69, 14.9315)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) C1R1_B_RET_B_Cu0.face(at (-353.427, -43.7356, 14.9315), at (-349.049, -41.437, 14.9315), at (-355.547, -43.7727, 14.9315), at (-346.751, -37.3754, 14.9315), at (-355.648, -43.8549, 14.9315), at (-349.182, -33.1817, 14.9315), at (-357.316, -43.9, 14.9315), at (-353.052, -30.7509, 14.9315), at (-358.639, -43.6163, 14.9315), at (-354.491, -29.8754, 14.9315), at (-358.844, -42.8442, 14.9315), at (-333.491, -29, 14.9315)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) C1R1_B_SIG_A_Cu0.face(at (-284.693, -76.0523, 14.9315), at (-285.486, -76, 14.914), at (-284.693, -76.0523, 14.9315), at (-284.691, -76, 14.9315), at (-284.693, -75.9477, 14.9315), at (-284.704, -76.1432, 14.9315), at (-284.693, -75.9477, 14.9315), at (-284.704, -75.8568, 14.9315), at (-284.725, -76.2322, 14.9315), at (-284.725, -76.2322, 14.9315), at (-284.725, -75.7678, 14.9315), at (-284.729, -76.2447, 14.9315)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) C1R1_B_SIG_B_Cu0.face(at (-361.014, -45.0143, 14.9315), at (-359.653, -44.347, 14.9315), at (-360.347, -43.653, 14.9315), at (-360, -44, 14.914), at (-358.986, -42.9857, 14.9315), at (-360.947, -44.7474, 14.9315), at (-359.453, -43.2526, 14.9315)) C1R1_B_SIG_B_Cu1.face(at (-313.014, -45.0143, 14.9315), at (-311.653, -44.347, 14.9315), at (-312.347, -43.653, 14.9315), at (-312, -44, 14.914), at (-310.986, -42.9857, 14.9315), at (-312.947, -44.7474, 14.9315), at (-311.453, -43.2526, 14.9315)) C1R1_B_SIG_B_Cu2.face(at (-265.014, -45.0143, 14.9315), at (-263.653, -44.347, 14.9315), at (-264.347, -43.653, 14.9315), at (-264, -44, 14.914), at (-262.986, -42.9857, 14.9315), at (-264.947, -44.7474, 14.9315), at (-263.453, -43.2526, 14.9315)) C1R1_B_SIG_B_Cu3.face(at (-216.347, -43.653, 14.9315), at (-217.014, -45.0143, 14.9315), at (-214.986, -42.9857, 14.9315), at (-216, -44, 14.914), at (-215.653, -44.347, 14.9315), at (-216.947, -44.7474, 14.9315), at (-215.453, -43.2526, 14.9315)) C1R1_B_SIG_B_Cu4.face(at (-284.693, -12.0523, 14.9315), at (-285.486, -12, 14.914), at (-284.693, -12.0523, 14.9315), at (-284.691, -12, 14.9315), at (-284.693, -11.9477, 14.9315), at (-284.704, -12.1432, 14.9315), at (-284.693, -11.9477, 14.9315), at (-284.704, -11.8568, 14.9315), at (-284.725, -12.2322, 14.9315), at (-284.725, -12.2322, 14.9315), at (-284.725, -11.7678, 14.9315), at (-284.729, -12.2447, 14.9315)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) C1R1_F_SIG_A_Cu0.face(at (-272.021, -74.3543, 15.7265), at (-285.491, -73.6406, 15.7265), at (-265.724, -75.068, 15.7265), at (-289.426, -57.6656, 15.744), at (-298.961, -74.3543, 15.7265), at (-259.428, -74.284, 15.7265), at (-305.257, -75.068, 15.7265), at (-255.932, -73.5, 15.7265), at (-311.553, -74.284, 15.7265), at (-252.435, -74.3441, 15.7265), at (-315.05, -73.5, 15.7265), at (-245.369, -75.1883, 15.7265)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) C1R1_F_SIG_B_Cu0.face(at (-360.48, -44.4805, 15.7265), at (-361.602, -44.9076, 15.7265), at (-360.908, -45.6016, 15.7265), at (-363.63, -47.63, 15.744), at (-362.696, -45.3614, 15.7265), at (-361.361, -46.696, 15.7265), at (-365.093, -45.041, 15.7265), at (-361.041, -49.0926, 15.7265), at (-367.169, -45.5318, 15.7265), at (-361.532, -51.1688, 15.7265), at (-365.296, -46.0225, 15.7265), at (-362.023, -49.2959, 15.7265)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) C1R1_F_SIG_B_Cu1.face(at (-312.48, -44.4805, 15.7265), at (-313.602, -44.9076, 15.7265), at (-312.908, -45.6016, 15.7265), at (-315.63, -47.63, 15.744), at (-314.696, -45.3614, 15.7265), at (-313.361, -46.696, 15.7265), at (-317.093, -45.041, 15.7265), at (-313.041, -49.0926, 15.7265), at (-319.169, -45.5318, 15.7265), at (-313.532, -51.1688, 15.7265), at (-317.296, -46.0225, 15.7265), at (-314.023, -49.2959, 15.7265)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) C1R1_F_SIG_B_Cu2.face(at (-264.48, -44.4805, 15.7265), at (-265.602, -44.9076, 15.7265), at (-264.908, -45.6016, 15.7265), at (-267.63, -47.63, 15.744), at (-266.696, -45.3614, 15.7265), at (-265.361, -46.696, 15.7265), at (-269.093, -45.041, 15.7265), at (-265.041, -49.0926, 15.7265), at (-271.169, -45.5318, 15.7265), at (-265.532, -51.1688, 15.7265), at (-269.296, -46.0225, 15.7265), at (-266.023, -49.2959, 15.7265)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) C1R1_F_SIG_B_Cu3.face(at (-216.48, -44.4805, 15.7265), at (-217.602, -44.9076, 15.7265), at (-216.908, -45.6016, 15.7265), at (-219.63, -47.63, 15.744), at (-218.696, -45.3614, 15.7265), at (-217.361, -46.696, 15.7265), at (-221.093, -45.041, 15.7265), at (-217.041, -49.0926, 15.7265), at (-223.169, -45.5318, 15.7265), at (-217.532, -51.1688, 15.7265), at (-221.296, -46.0225, 15.7265), at (-218.023, -49.2959, 15.7265)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) C1R1_F_SIG_B_Cu4.face(at (-356.679, -41.8378, 15.7265), at (-356.645, -41.3386, 15.7265), at (-357.144, -42.3025, 15.7265), at (-286.238, -26.7864, 15.744), at (-356.645, -41.2694, 15.7265), at (-358.391, -43.0845, 15.7265), at (-356.679, -34.0233, 15.7265), at (-359.52, -43.5195, 15.7265), at (-349.087, -26.8117, 15.7265), at (-359.085, -42.3905, 15.7265), at (-341.495, -26.621, 15.7265), at (-358.303, -33.3984, 15.7265)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) C1R2_B_E1_Q2_Cu0.face(at (-179.079, -41.407, 14.9315), at (-173.594, -43.7325, 14.9315), at (-181.404, -37.298, 14.9315), at (-169.351, -42.6488, 14.9315), at (-178.945, -33.0552, 14.9315), at (-168.268, -38.406, 14.9315), at (-174.702, -30.596, 14.9315), at (-170.593, -32.9214, 14.9315), at (-171.905, -33.3389, 14.9315), at (-170.459, -36.8386, 14.9315), at (-171.783, -40.2166, 14.9315), at (-175.161, -41.5408, 14.9315)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) C1R2_B_E1_Q3_Cu0.face(at (-174.625, -57.2491, 14.9315), at (-170.563, -54.9506, 14.9315), at (-178.818, -54.8183, 14.9315), at (-168.264, -49.5294, 14.9315), at (-181.249, -50.6246, 14.9315), at (-169.336, -45.3356, 14.9315), at (-178.951, -46.563, 14.9315), at (-173.529, -44.2644, 14.9315), at (-175.079, -46.4308, 14.9315), at (-171.74, -47.7397, 14.9315), at (-170.431, -51.0787, 14.9315), at (-171.86, -54.5379, 14.9315)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) C1R2_B_E2_Q2_Cu0.face(at (-131.079, -41.407, 14.9315), at (-125.594, -43.7325, 14.9315), at (-133.404, -37.298, 14.9315), at (-121.351, -42.6488, 14.9315), at (-130.945, -33.0552, 14.9315), at (-120.268, -38.406, 14.9315), at (-126.702, -30.596, 14.9315), at (-122.593, -32.9214, 14.9315), at (-123.905, -33.3389, 14.9315), at (-122.459, -36.8386, 14.9315), at (-123.783, -40.2166, 14.9315), at (-127.161, -41.5408, 14.9315)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) C1R2_B_E2_Q3_Cu0.face(at (-126.625, -57.2491, 14.9315), at (-122.563, -54.9506, 14.9315), at (-130.818, -54.8183, 14.9315), at (-120.264, -49.5294, 14.9315), at (-133.249, -50.6246, 14.9315), at (-121.336, -45.3356, 14.9315), at (-130.951, -46.563, 14.9315), at (-125.529, -44.2644, 14.9315), at (-127.079, -46.4308, 14.9315), at (-123.74, -47.7397, 14.9315), at (-122.431, -51.0787, 14.9315), at (-123.86, -54.5379, 14.9315)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) C1R2_B_E3_Q2_Cu0.face(at (-83.0786, -41.407, 14.9315), at (-77.594, -43.7325, 14.9315), at (-85.404, -37.298, 14.9315), at (-73.3512, -42.6488, 14.9315), at (-82.9448, -33.0552, 14.9315), at (-72.2675, -38.406, 14.9315), at (-78.702, -30.596, 14.9315), at (-74.593, -32.9214, 14.9315), at (-75.905, -33.3389, 14.9315), at (-74.4592, -36.8386, 14.9315), at (-75.7834, -40.2166, 14.9315), at (-79.1614, -41.5408, 14.9315)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) C1R2_B_E3_Q3_Cu0.face(at (-78.6246, -57.2491, 14.9315), at (-74.563, -54.9506, 14.9315), at (-82.8183, -54.8183, 14.9315), at (-72.2644, -49.5294, 14.9315), at (-85.2491, -50.6246, 14.9315), at (-73.3356, -45.3356, 14.9315), at (-82.9506, -46.563, 14.9315), at (-77.5294, -44.2644, 14.9315), at (-79.0787, -46.4308, 14.9315), at (-75.7397, -47.7397, 14.9315), at (-74.4308, -51.0787, 14.9315), at (-75.8599, -54.5379, 14.9315)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) C1R2_B_E4_Q2_Cu0.face(at (-35.0786, -41.407, 14.9315), at (-29.594, -43.7325, 14.9315), at (-37.404, -37.298, 14.9315), at (-25.3512, -42.6488, 14.9315), at (-34.9448, -33.0552, 14.9315), at (-24.2675, -38.406, 14.9315), at (-30.702, -30.596, 14.9315), at (-26.593, -32.9214, 14.9315), at (-27.905, -33.3389, 14.9315), at (-26.4592, -36.8386, 14.9315), at (-27.7834, -40.2166, 14.9315), at (-31.1614, -41.5408, 14.9315)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) C1R2_B_E4_Q3_Cu0.face(at (-30.6246, -57.2491, 14.9315), at (-26.563, -54.9506, 14.9315), at (-34.8183, -54.8183, 14.9315), at (-24.2644, -49.5294, 14.9315), at (-37.2491, -50.6246, 14.9315), at (-25.3356, -45.3356, 14.9315), at (-34.9506, -46.563, 14.9315), at (-29.5294, -44.2644, 14.9315), at (-31.0787, -46.4308, 14.9315), at (-27.7397, -47.7397, 14.9315), at (-26.4308, -51.0787, 14.9315), at (-27.8599, -54.5379, 14.9315)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) C1R2_B_RET_A_Cu0.face(at (-72.0644, -49.5294, 14.9315), at (-72.066, -52.7364, 14.9315), at (-72.2508, -46.1375, 14.9315), at (-72.0675, -52.787, 14.9315), at (-72.4352, -45.9375, 14.9315), at (-72.2792, -53.0476, 14.9315), at (-72.3974, -45.7811, 14.9315), at (-72.4908, -59.1296, 14.9315), at (-72.3121, -45.4997, 14.9315), at (-60.4908, -65, 14.9315), at (-72.2078, -45.2456, 14.9315), at (-48.4908, -69, 14.9315)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) C1R2_B_RET_B_Cu0.face(at (-161.427, -43.7356, 14.9315), at (-157.049, -41.437, 14.9315), at (-163.547, -43.7727, 14.9315), at (-154.751, -37.3754, 14.9315), at (-163.648, -43.8549, 14.9315), at (-157.182, -33.1817, 14.9315), at (-165.316, -43.9, 14.9315), at (-161.052, -30.7509, 14.9315), at (-166.639, -43.6163, 14.9315), at (-162.491, -29.8754, 14.9315), at (-166.844, -42.8442, 14.9315), at (-141.491, -29, 14.9315)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) C1R2_B_SIG_A_Cu0.face(at (-92.6925, -76.0523, 14.9315), at (-93.486, -76, 14.914), at (-92.6925, -76.0523, 14.9315), at (-92.6908, -76, 14.9315), at (-92.6925, -75.9477, 14.9315), at (-92.7038, -76.1432, 14.9315), at (-92.6925, -75.9477, 14.9315), at (-92.7038, -75.8568, 14.9315), at (-92.7253, -76.2322, 14.9315), at (-92.7253, -76.2322, 14.9315), at (-92.7253, -75.7678, 14.9315), at (-92.7292, -76.2447, 14.9315)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) C1R2_B_SIG_B_Cu0.face(at (-169.014, -45.0143, 14.9315), at (-167.653, -44.347, 14.9315), at (-168.347, -43.653, 14.9315), at (-168, -44, 14.914), at (-166.986, -42.9857, 14.9315), at (-168.947, -44.7474, 14.9315), at (-167.453, -43.2526, 14.9315)) C1R2_B_SIG_B_Cu1.face(at (-121.014, -45.0143, 14.9315), at (-119.653, -44.347, 14.9315), at (-120.347, -43.653, 14.9315), at (-120, -44, 14.914), at (-118.986, -42.9857, 14.9315), at (-120.947, -44.7474, 14.9315), at (-119.453, -43.2526, 14.9315)) C1R2_B_SIG_B_Cu2.face(at (-73.0143, -45.0143, 14.9315), at (-71.653, -44.347, 14.9315), at (-72.347, -43.653, 14.9315), at (-72, -44, 14.914), at (-70.9857, -42.9857, 14.9315), at (-72.9474, -44.7474, 14.9315), at (-71.4526, -43.2526, 14.9315)) C1R2_B_SIG_B_Cu3.face(at (-24.347, -43.653, 14.9315), at (-25.0143, -45.0143, 14.9315), at (-22.9857, -42.9857, 14.9315), at (-24, -44, 14.914), at (-23.653, -44.347, 14.9315), at (-24.9474, -44.7474, 14.9315), at (-23.4526, -43.2526, 14.9315)) C1R2_B_SIG_B_Cu4.face(at (-92.6925, -12.0523, 14.9315), at (-93.486, -12, 14.914), at (-92.6925, -12.0523, 14.9315), at (-92.6908, -12, 14.9315), at (-92.6925, -11.9477, 14.9315), at (-92.7038, -12.1432, 14.9315), at (-92.6925, -11.9477, 14.9315), at (-92.7038, -11.8568, 14.9315), at (-92.7253, -12.2322, 14.9315), at (-92.7253, -12.2322, 14.9315), at (-92.7253, -11.7678, 14.9315), at (-92.7292, -12.2447, 14.9315)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) C1R2_F_SIG_A_Cu0.face(at (-80.0206, -74.3543, 15.7265), at (-93.4908, -73.6406, 15.7265), at (-73.7244, -75.068, 15.7265), at (-97.4257, -57.6656, 15.744), at (-106.961, -74.3543, 15.7265), at (-67.4283, -74.284, 15.7265), at (-113.257, -75.068, 15.7265), at (-63.9316, -73.5, 15.7265), at (-119.553, -74.284, 15.7265), at (-60.4348, -74.3441, 15.7265), at (-123.05, -73.5, 15.7265), at (-53.3687, -75.1883, 15.7265)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) C1R2_F_SIG_B_Cu0.face(at (-168.48, -44.4805, 15.7265), at (-169.602, -44.9076, 15.7265), at (-168.908, -45.6016, 15.7265), at (-171.63, -47.63, 15.744), at (-170.696, -45.3614, 15.7265), at (-169.361, -46.696, 15.7265), at (-173.093, -45.041, 15.7265), at (-169.041, -49.0926, 15.7265), at (-175.169, -45.5318, 15.7265), at (-169.532, -51.1688, 15.7265), at (-173.296, -46.0225, 15.7265), at (-170.023, -49.2959, 15.7265)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)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 Frequency=0GHz Layers{Layer1{Thickness=0.0254um Material=Ouro_vol_nominal} Layer2{Thickness=4.5um Material=NiP_vol_nominal} Layer3{LayerType=1 Thickness=0 Material=Cobre_vol_Groiss}}
  Open1: Radiation Objects=RadiatingSurface
  C1R1_A: Lumped Port Objects=C1R1_A_ext LumpedPortType=Modal Modes{Mode1{IntLine{(-284.96583, -76, 14.769) -> (-283.97583, -76, 14.769)} CharImp=Zpi RenormImp=50ohm}} Impedance=50ohm
  C1R1_B: Lumped Port Objects=C1R1_B_ext LumpedPortType=Modal Modes{Mode1{IntLine{(-284.96583, -12, 14.769) -> (-283.97583, -12, 14.769)} CharImp=Zpi RenormImp=50ohm}} Impedance=50ohm
  C1R2_A: Lumped Port Objects=C1R2_A_ext LumpedPortType=Modal Modes{Mode1{IntLine{(-92.965832, -76, 14.769) -> (-91.975832, -76, 14.769)} CharImp=Zpi RenormImp=50ohm}} Impedance=50ohm
  C1R2_B: Lumped Port Objects=C1R2_B_ext LumpedPortType=Modal Modes{Mode1{IntLine{(-92.965832, -12, 14.769) -> (-91.975832, -12, 14.769)} CharImp=Zpi RenormImp=50ohm}} Impedance=50ohm
  C1R3_A: Lumped Port Objects=C1R3_A_ext LumpedPortType=Modal Modes{Mode1{IntLine{(99.034168, -76, 14.769) -> (100.02417, -76, 14.769)} CharImp=Zpi RenormImp=50ohm}} Impedance=50ohm
  C1R3_B: Lumped Port Objects=C1R3_B_ext LumpedPortType=Modal Modes{Mode1{IntLine{(99.034168, -12, 14.769) -> (100.02417, -12, 14.769)} CharImp=Zpi RenormImp=50ohm}} Impedance=50ohm
  C1R4_A: Lumped Port Objects=C1R4_A_ext LumpedPortType=Modal Modes{Mode1{IntLine{(291.03417, -76, 14.769) -> (292.02417, -76, 14.769)} CharImp=Zpi RenormImp=50ohm}} Impedance=50ohm
  C1R4_B: Lumped Port Objects=C1R4_B_ext LumpedPortType=Modal Modes{Mode1{IntLine{(291.03417, -12, 14.769) -> (292.02417, -12, 14.769)} CharImp=Zpi RenormImp=50ohm}} Impedance=50ohm
  C2R1_A: Lumped Port Objects=C2R1_A_ext LumpedPortType=Modal Modes{Mode1{IntLine{(-284.96583, 12, 14.769) -> (-283.97583, 12, 14.769)} CharImp=Zpi RenormImp=50ohm}} Impedance=50ohm
  C2R1_B: Lumped Port Objects=C2R1_B_ext LumpedPortType=Modal Modes{Mode1{IntLine{(-284.96583, 76, 14.769) -> (-283.97583, 76, 14.769)} CharImp=Zpi RenormImp=50ohm}} Impedance=50ohm
  C2R2_A: Lumped Port Objects=C2R2_A_ext LumpedPortType=Modal Modes{Mode1{IntLine{(-92.965832, 12, 14.769) -> (-91.975832, 12, 14.769)} CharImp=Zpi RenormImp=50ohm}} Impedance=50ohm
  C2R2_B: Lumped Port Objects=C2R2_B_ext LumpedPortType=Modal Modes{Mode1{IntLine{(-92.965832, 76, 14.769) -> (-91.975832, 76, 14.769)} CharImp=Zpi RenormImp=50ohm}} Impedance=50ohm
  C2R3_A: Lumped Port Objects=C2R3_A_ext LumpedPortType=Modal Modes{Mode1{IntLine{(99.034168, 12, 14.769) -> (100.02417, 12, 14.769)} CharImp=Zpi RenormImp=50ohm}} Impedance=50ohm
  C2R3_B: Lumped Port Objects=C2R3_B_ext LumpedPortType=Modal Modes{Mode1{IntLine{(99.034168, 76, 14.769) -> (100.02417, 76, 14.769)} CharImp=Zpi RenormImp=50ohm}} Impedance=50ohm
  C2R4_A: Lumped Port Objects=C2R4_A_ext LumpedPortType=Modal Modes{Mode1{IntLine{(291.03417, 12, 14.769) -> (292.02417, 12, 14.769)} CharImp=Zpi RenormImp=50ohm}} Impedance=50ohm
  C2R4_B: Lumped Port Objects=C2R4_B_ext LumpedPortType=Modal Modes{Mode1{IntLine{(291.03417, 76, 14.769) -> (292.02417, 76, 14.769)} CharImp=Zpi RenormImp=50ohm}} Impedance=50ohm
mesh:
  initial mesh: GlobalCurvilinear{Apply} MeshMethod=AnsoftClassic
setups:
  Centro: HfssDriven Frequency=5.17GHz MaxDeltaS=0.05 MaximumPasses=6 MinimumPasses=2 MinimumConvergedPasses=2 PercentRefinement=20 BasisOrder=1 DoLambdaRefine=false PortAccuracy=2 DrivenSolverType="Direct Solver" SaveRadFieldsOnly ExpressionCache{CacheItem{Title=P2M19_Campo_00 Expression=dB(RealizedGainTotal) Intrinsics="Phi='90deg' Theta='0deg'" TraceID=145 ReportType=3} CacheItem{Title=P2M19_Campo_01 Expression=dB(RealizedGainTotal) Intrinsics="Phi='90deg' Theta='-10deg'" TraceID=146 ReportType=3} CacheItem{Title=P2M19_Campo_02 Expression=dB(RealizedGainTotal) Intrinsics="Phi='90deg' Theta='10deg'" TraceID=147 ReportType=3} CacheItem{Title=P2M19_Campo_03 Expression=dB(RealizedGainTotal) Intrinsics="Phi='90deg' Theta='-54deg'" TraceID=148 ReportType=3} CacheItem{Title=P2M19_Campo_04 Expression=dB(RealizedGainTotal) Intrinsics="Phi='90deg' Theta='54deg'" TraceID=149 ReportType=3} CacheItem{Title=P2M19_Campo_05 Expression=dB(RealizedGainTotal) Intrinsics="Phi='0deg' Theta='-1.75deg'" TraceID=150 ReportType=3} CacheItem{Title=P2M19_Campo_06 Expression=dB(RealizedGainTotal) Intrinsics="Phi='0deg' Theta='1.75deg'" TraceID=151 ReportType=3} CacheItem{Title=P2M19_Campo_07 Expression=dB(RealizedGainTotal) Intrinsics="Phi='0deg' Theta='-45deg'" TraceID=152 ReportType=3} CacheItem{Title=P2M19_Campo_08 Expression=dB(RealizedGainTotal) Intrinsics="Phi='0deg' Theta='45deg'" TraceID=153 ReportType=3}}
source amplitudes:
  C1R1_A:1, C1R1_B:1, C1R2_A:1, C1R2_B:1, C1R3_A:1, C1R3_B:1, C1R4_A:1, C1R4_B:1, C2R1_A:1, C2R1_B:1, C2R2_A:1, C2R2_B:1, C2R3_A:1, C2R3_B:1, C2R4_A:1, C2R4_B:1: 0.0625W 0deg
radiation setups:
  3D: Infinite Sphere Theta=0deg..180deg step 2deg Phi=-180deg..180deg step 2deg
  Elevation: Infinite Sphere Theta=-180deg..180deg step 1deg Phi=0deg..90deg step 90deg
  Azimuth: Infinite Sphere Theta=90deg..90deg step 0deg Phi=-180deg..180deg step 1deg
  HV: Infinite Sphere Theta=-180deg..180deg step 0.25deg Phi=0deg..90deg step 90deg
  Centro_fino: Infinite Sphere Theta=-20deg..20deg step 0.05deg Phi=0deg..90deg step 90deg
  Potencia: Infinite Sphere Theta=0deg..180deg step 2deg Phi=0deg..360deg step 2deg
reports:
  ALL_H: dB(RealizedGainTotal), dB(GainTotal), dB(DirTotal), re(rETheta), im(rETheta), re(rEPhi), im(rEPhi) vs Theta on Centro : LastAdaptive, HV [Phi=90deg Freq=5170MHz]
  ALL_V: dB(RealizedGainTotal), dB(GainTotal), dB(DirTotal), re(rETheta), im(rETheta), re(rEPhi), im(rEPhi) vs Theta on Centro : LastAdaptive, HV [Phi=0deg Freq=5170MHz]
  POL_A_H: dB(RealizedGainTotal), dB(GainTotal), dB(DirTotal), re(rETheta), im(rETheta), re(rEPhi), im(rEPhi) vs Theta on Centro : LastAdaptive, HV [Phi=90deg Freq=5170MHz]
  POL_A_V: dB(RealizedGainTotal), dB(GainTotal), dB(DirTotal), re(rETheta), im(rETheta), re(rEPhi), im(rEPhi) vs Theta on Centro : LastAdaptive, HV [Phi=0deg Freq=5170MHz]
  POL_B_H: dB(RealizedGainTotal), dB(GainTotal), dB(DirTotal), re(rETheta), im(rETheta), re(rEPhi), im(rEPhi) vs Theta on Centro : LastAdaptive, HV [Phi=90deg Freq=5170MHz]
  POL_B_V: dB(RealizedGainTotal), dB(GainTotal), dB(DirTotal), re(rETheta), im(rETheta), re(rEPhi), im(rEPhi) vs Theta on Centro : LastAdaptive, HV [Phi=0deg Freq=5170MHz]
  C1R1_A_H: dB(RealizedGainTotal), dB(GainTotal), dB(DirTotal), re(rETheta), im(rETheta), re(rEPhi), im(rEPhi) vs Theta on Centro : LastAdaptive, HV [Phi=90deg Freq=5170MHz]
  C1R1_A_V: dB(RealizedGainTotal), dB(GainTotal), dB(DirTotal), re(rETheta), im(rETheta), re(rEPhi), im(rEPhi) vs Theta on Centro : LastAdaptive, HV [Phi=0deg Freq=5170MHz]
  C1R1_B_H: dB(RealizedGainTotal), dB(GainTotal), dB(DirTotal), re(rETheta), im(rETheta), re(rEPhi), im(rEPhi) vs Theta on Centro : LastAdaptive, HV [Phi=90deg Freq=5170MHz]
  C1R1_B_V: dB(RealizedGainTotal), dB(GainTotal), dB(DirTotal), re(rETheta), im(rETheta), re(rEPhi), im(rEPhi) vs Theta on Centro : LastAdaptive, HV [Phi=0deg Freq=5170MHz]
  C1R2_A_H: dB(RealizedGainTotal), dB(GainTotal), dB(DirTotal), re(rETheta), im(rETheta), re(rEPhi), im(rEPhi) vs Theta on Centro : LastAdaptive, HV [Phi=90deg Freq=5170MHz]
  C1R2_A_V: dB(RealizedGainTotal), dB(GainTotal), dB(DirTotal), re(rETheta), im(rETheta), re(rEPhi), im(rEPhi) vs Theta on Centro : LastAdaptive, HV [Phi=0deg Freq=5170MHz]
  C1R2_B_H: dB(RealizedGainTotal), dB(GainTotal), dB(DirTotal), re(rETheta), im(rETheta), re(rEPhi), im(rEPhi) vs Theta on Centro : LastAdaptive, HV [Phi=90deg Freq=5170MHz]
  C1R2_B_V: dB(RealizedGainTotal), dB(GainTotal), dB(DirTotal), re(rETheta), im(rETheta), re(rEPhi), im(rEPhi) vs Theta on Centro : LastAdaptive, HV [Phi=0deg Freq=5170MHz]
  C1R3_A_H: dB(RealizedGainTotal), dB(GainTotal), dB(DirTotal), re(rETheta), im(rETheta), re(rEPhi), im(rEPhi) vs Theta on Centro : LastAdaptive, HV [Phi=90deg Freq=5170MHz]
  C1R3_A_V: dB(RealizedGainTotal), dB(GainTotal), dB(DirTotal), re(rETheta), im(rETheta), re(rEPhi), im(rEPhi) vs Theta on Centro : LastAdaptive, HV [Phi=0deg Freq=5170MHz]
  C1R3_B_H: dB(RealizedGainTotal), dB(GainTotal), dB(DirTotal), re(rETheta), im(rETheta), re(rEPhi), im(rEPhi) vs Theta on Centro : LastAdaptive, HV [Phi=90deg Freq=5170MHz]
  C1R3_B_V: dB(RealizedGainTotal), dB(GainTotal), dB(DirTotal), re(rETheta), im(rETheta), re(rEPhi), im(rEPhi) vs Theta on Centro : LastAdaptive, HV [Phi=0deg Freq=5170MHz]
  C1R4_A_H: dB(RealizedGainTotal), dB(GainTotal), dB(DirTotal), re(rETheta), im(rETheta), re(rEPhi), im(rEPhi) vs Theta on Centro : LastAdaptive, HV [Phi=90deg Freq=5170MHz]
  C1R4_A_V: dB(RealizedGainTotal), dB(GainTotal), dB(DirTotal), re(rETheta), im(rETheta), re(rEPhi), im(rEPhi) vs Theta on Centro : LastAdaptive, HV [Phi=0deg Freq=5170MHz]
  C1R4_B_H: dB(RealizedGainTotal), dB(GainTotal), dB(DirTotal), re(rETheta), im(rETheta), re(rEPhi), im(rEPhi) vs Theta on Centro : LastAdaptive, HV [Phi=90deg Freq=5170MHz]
  C1R4_B_V: dB(RealizedGainTotal), dB(GainTotal), dB(DirTotal), re(rETheta), im(rETheta), re(rEPhi), im(rEPhi) vs Theta on Centro : LastAdaptive, HV [Phi=0deg Freq=5170MHz]
  C2R1_A_H: dB(RealizedGainTotal), dB(GainTotal), dB(DirTotal), re(rETheta), im(rETheta), re(rEPhi), im(rEPhi) vs Theta on Centro : LastAdaptive, HV [Phi=90deg Freq=5170MHz]
  C2R1_A_V: dB(RealizedGainTotal), dB(GainTotal), dB(DirTotal), re(rETheta), im(rETheta), re(rEPhi), im(rEPhi) vs Theta on Centro : LastAdaptive, HV [Phi=0deg Freq=5170MHz]
  C2R1_B_H: dB(RealizedGainTotal), dB(GainTotal), dB(DirTotal), re(rETheta), im(rETheta), re(rEPhi), im(rEPhi) vs Theta on Centro : LastAdaptive, HV [Phi=90deg Freq=5170MHz]
  C2R1_B_V: dB(RealizedGainTotal), dB(GainTotal), dB(DirTotal), re(rETheta), im(rETheta), re(rEPhi), im(rEPhi) vs Theta on Centro : LastAdaptive, HV [Phi=0deg Freq=5170MHz]
  C2R2_A_H: dB(RealizedGainTotal), dB(GainTotal), dB(DirTotal), re(rETheta), im(rETheta), re(rEPhi), im(rEPhi) vs Theta on Centro : LastAdaptive, HV [Phi=90deg Freq=5170MHz]
  C2R2_A_V: dB(RealizedGainTotal), dB(GainTotal), dB(DirTotal), re(rETheta), im(rETheta), re(rEPhi), im(rEPhi) vs Theta on Centro : LastAdaptive, HV [Phi=0deg Freq=5170MHz]
  C2R2_B_H: dB(RealizedGainTotal), dB(GainTotal), dB(DirTotal), re(rETheta), im(rETheta), re(rEPhi), im(rEPhi) vs Theta on Centro : LastAdaptive, HV [Phi=90deg Freq=5170MHz]
  C2R2_B_V: dB(RealizedGainTotal), dB(GainTotal), dB(DirTotal), re(rETheta), im(rETheta), re(rEPhi), im(rEPhi) vs Theta on Centro : LastAdaptive, HV [Phi=0deg Freq=5170MHz]
  C2R3_A_H: dB(RealizedGainTotal), dB(GainTotal), dB(DirTotal), re(rETheta), im(rETheta), re(rEPhi), im(rEPhi) vs Theta on Centro : LastAdaptive, HV [Phi=90deg Freq=5170MHz]
  C2R3_A_V: dB(RealizedGainTotal), dB(GainTotal), dB(DirTotal), re(rETheta), im(rETheta), re(rEPhi), im(rEPhi) vs Theta on Centro : LastAdaptive, HV [Phi=0deg Freq=5170MHz]
  C2R3_B_H: dB(RealizedGainTotal), dB(GainTotal), dB(DirTotal), re(rETheta), im(rETheta), re(rEPhi), im(rEPhi) vs Theta on Centro : LastAdaptive, HV [Phi=90deg Freq=5170MHz]
  C2R3_B_V: dB(RealizedGainTotal), dB(GainTotal), dB(DirTotal), re(rETheta), im(rETheta), re(rEPhi), im(rEPhi) vs Theta on Centro : LastAdaptive, HV [Phi=0deg Freq=5170MHz]
  C2R4_A_H: dB(RealizedGainTotal), dB(GainTotal), dB(DirTotal), re(rETheta), im(rETheta), re(rEPhi), im(rEPhi) vs Theta on Centro : LastAdaptive, HV [Phi=90deg Freq=5170MHz]
  C2R4_A_V: dB(RealizedGainTotal), dB(GainTotal), dB(DirTotal), re(rETheta), im(rETheta), re(rEPhi), im(rEPhi) vs Theta on Centro : LastAdaptive, HV [Phi=0deg Freq=5170MHz]
  C2R4_B_H: dB(RealizedGainTotal), dB(GainTotal), dB(DirTotal), re(rETheta), im(rETheta), re(rEPhi), im(rEPhi) vs Theta on Centro : LastAdaptive, HV [Phi=90deg Freq=5170MHz]
  C2R4_B_V: dB(RealizedGainTotal), dB(GainTotal), dB(DirTotal), re(rETheta), im(rETheta), re(rEPhi), im(rEPhi) vs Theta on Centro : LastAdaptive, HV [Phi=0deg Freq=5170MHz]
  ALL_H_fino: dB(RealizedGainTotal), re(rETheta), im(rETheta), re(rEPhi), im(rEPhi) vs Theta on Centro : LastAdaptive, Centro_fino [Phi=90deg Freq=5170MHz]
  ALL_V_fino: dB(RealizedGainTotal), re(rETheta), im(rETheta), re(rEPhi), im(rEPhi) vs Theta on Centro : LastAdaptive, Centro_fino [Phi=0deg Freq=5170MHz]
  ALL_Potencia: dB(RealizedGainTotal) vs Theta on Centro : LastAdaptive, Potencia [Phi=all Freq=5170MHz]
