# Ansys Electronics Desktop project, version 2024.2
materials:
  vacuum: permittivity=1
  RO4350B_R01: permittivity=3.66 dielectric_loss_tangent=0.0037
  POM_nom: permittivity=3.4 dielectric_loss_tangent=0.01
  ZYF300: permittivity=2.94 dielectric_loss_tangent=0.0016
  PTFE_terminal: permittivity=2.0363635 dielectric_loss_tangent=0.00027683055
  AL5052: conductivity=20000000
  SAC305: conductivity=7575758
  copper: permeability=0.999991 conductivity=58000000
  NiP_vol_nominal: permeability=1 conductivity=1500000
  Ouro_vol_nominal: permeability=1 conductivity=41000000
  Cobre_vol_Groiss: permeability=1 conductivity=28688604

design PCB_separada (HFSS, HFSS Hybrid Modal Network, model units mm)
geometry:
  Refletor_Al2mm [AL5052] = imported_body(D:\dev\EMBRAER\P2M21\R09_Divisor_Simetria\v08_B145_inferior05_terra33\cad\AL5052.step)
  PTFE_B, PTFE_A [PTFE_terminal] = imported_body(D:\dev\EMBRAER\P2M21\R09_Divisor_Simetria\v08_B145_inferior05_terra33\cad\PTFE_terminal.step)
  PCB_RO4350B [RO4350B_R01] = imported_body(D:\dev\EMBRAER\P2M21\R09_Divisor_Simetria\v08_B145_inferior05_terra33\cad\RO4350B_R01.step)
  Solda_B, Solda_A [SAC305] = imported_body(D:\dev\EMBRAER\P2M21\R09_Divisor_Simetria\v08_B145_inferior05_terra33\cad\SAC305.step)
  PTH_B, Blindagem_B, Vivo_B, PTH_A, Blindagem_A, Vivo_A, Via_3, Via_2, Via_1, Via_0 [copper] = imported_body(D:\dev\EMBRAER\P2M21\R09_Divisor_Simetria\v08_B145_inferior05_terra33\cad\copper.step)
  F_SIG_B_Cu2, F_SIG_B_Cu1, F_SIG_B_Cu0, F_SIG_A_Cu0, B_SIG_B_Cu2, B_SIG_B_Cu1, B_SIG_B_Cu0, B_SIG_A_Cu0, B_RET_B_Cu0, B_RET_A_Cu0, B_E2_Q3_Cu0, B_E2_Q2_Cu0, B_E1_Q3_Cu0, B_E1_Q2_Cu0 [Cobre_vol_Groiss] = imported_body(D:\dev\EMBRAER\P2M21\R09_Divisor_Simetria\v08_B145_inferior05_terra33\cad\folha_cu.step)
  A_ext = circle(normal=Z, centre=(2.5091684mm, -18mm, -33.39mm), radius=1.515mm)
  A_int = circle(normal=Z, centre=(2.5091684mm, -18mm, -33.39mm), radius=0.45975mm)
  A_ext.subtract(A_int)
  B_ext = circle(normal=Z, centre=(2.5091684mm, 18mm, -33.39mm), radius=1.515mm)
  B_int = circle(normal=Z, centre=(2.5091684mm, 18mm, -33.39mm), radius=0.45975mm)
  B_ext.subtract(B_int)
  RadiatingSurface [vacuum] = region(absolute_offset=19.646365mm on all sides)
boundaries and excitations:
  ENIG_faces_expostas: Layered Impedance Faces=B_E1_Q2_Cu0.face(at (-35.0786, 2.59297, 16.5925), at (-29.594, 0.267527, 16.5925), at (-37.404, 6.70202, 16.5925), at (-25.3512, 1.35121, 16.5925), at (-34.9448, 10.9448, 16.5925), at (-24.2675, 5.59403, 16.5925), at (-30.702, 13.404, 16.5925), at (-26.593, 11.0786, 16.5925), at (-27.905, 10.6611, 16.5925), at (-26.4592, 7.16143, 16.5925), at (-27.7834, 3.7834, 16.5925), at (-31.1614, 2.45921, 16.5925)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) B_E1_Q3_Cu0.face(at (-30.6246, -13.2491, 16.5925), at (-26.563, -10.9506, 16.5925), at (-34.8183, -10.8183, 16.5925), at (-24.2644, -5.52938, 16.5925), at (-37.2491, -6.62457, 16.5925), at (-25.3356, -1.3356, 16.5925), at (-34.9506, -2.56301, 16.5925), at (-29.5294, -0.264435, 16.5925), at (-31.0787, -2.43079, 16.5925), at (-27.7397, -3.73968, 16.5925), at (-26.4308, -7.07867, 16.5925), at (-27.8599, -10.5379, 16.5925)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) B_E2_Q2_Cu0.face(at (12.9214, 2.59297, 16.5925), at (18.406, 0.267527, 16.5925), at (10.596, 6.70202, 16.5925), at (22.6488, 1.35121, 16.5925), at (13.0552, 10.9448, 16.5925), at (23.7325, 5.59403, 16.5925), at (17.298, 13.404, 16.5925), at (21.407, 11.0786, 16.5925), at (20.095, 10.6611, 16.5925), at (21.5408, 7.16143, 16.5925), at (20.2166, 3.7834, 16.5925), at (16.8386, 2.45921, 16.5925)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) B_E2_Q3_Cu0.face(at (17.3754, -13.2491, 16.5925), at (21.437, -10.9506, 16.5925), at (13.1817, -10.8183, 16.5925), at (23.7356, -5.52938, 16.5925), at (10.7509, -6.62457, 16.5925), at (22.6644, -1.3356, 16.5925), at (13.0494, -2.56301, 16.5925), at (18.4706, -0.264435, 16.5925), at (16.9213, -2.43079, 16.5925), at (20.2603, -3.73968, 16.5925), at (21.5692, -7.07867, 16.5925), at (20.1401, -10.5379, 16.5925)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) B_RET_A_Cu0.face(at (3.7577, -20.3358, 16.5925), at (3.9078, -20.2492, 16.5925), at (3.60226, -20.4125, 16.5925), at (4.05191, -20.1529, 16.5925), at (3.44213, -20.4788, 16.5925), at (4.18941, -20.0474, 16.5925), at (3.27801, -20.5345, 16.5925), at (4.31972, -19.9331, 16.5925), at (3.1106, -20.5794, 16.5925), at (4.44227, -19.8105, 16.5925), at (2.94061, -20.6132, 16.5925), at (4.54146, -19.6986, 16.5925)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) B_RET_B_Cu0.face(at (-13.0494, 2.56301, 16.5925), at (-10.7509, 6.62457, 16.5925), at (-18.4706, 0.264435, 16.5925), at (-13.1817, 10.8183, 16.5925), at (-22.6644, 1.3356, 16.5925), at (-17.3754, 13.2491, 16.5925), at (-23.7356, 5.52938, 16.5925), at (-19.4896, 12.8979, 16.5925), at (-23.4382, 8.94936, 16.5925), at (-19.8408, 14.4484, 16.5925), at (-23.1408, 14.4484, 16.5925), at (-14.749, 16.35, 16.5925)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) B_SIG_A_Cu0.face(at (2.50917, -18, 16.575), at (3.20524, -18.3943, 16.5925), at (3.30917, -18, 16.5925), at (3.26879, -18.251, 16.5925), at (3.2688, -17.7491, 16.5925), at (3.20525, -17.6057, 16.5925), at (3.08857, -18.5516, 16.5925), at (3.08858, -17.4484, 16.5925), at (3.00136, -18.6307, 16.5925), at (3.00137, -17.3693, 16.5925), at (2.50917, -18.8, 16.5925), at (2.50919, -17.2, 16.5925)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) B_SIG_B_Cu0.face(at (-23.653, -0.347013, 16.5925), at (-22.9857, 1.01434, 16.5925), at (-25.0143, -1.01434, 16.5925), at (-24, 0, 16.575), at (-24.347, 0.347013, 16.5925), at (-24.9474, -0.747412, 16.5925), at (-23.4526, 0.747412, 16.5925)) B_SIG_B_Cu1.face(at (22.9857, -1.01434, 16.5925), at (24.347, -0.347013, 16.5925), at (23.653, 0.347013, 16.5925), at (24, 0, 16.575), at (25.0143, 1.01434, 16.5925), at (23.0526, -0.747412, 16.5925), at (24.5474, 0.747412, 16.5925)) B_SIG_B_Cu2.face(at (2.50917, 18, 16.575), at (3.20524, 17.6057, 16.5925), at (3.30917, 18, 16.5925), at (3.26879, 17.749, 16.5925), at (3.2688, 18.2509, 16.5925), at (3.20525, 18.3943, 16.5925), at (3.08857, 17.4484, 16.5925), at (3.08858, 18.5516, 16.5925), at (3.00136, 17.3693, 16.5925), at (3.00137, 18.6307, 16.5925), at (2.50917, 17.2, 16.5925), at (2.50919, 18.8, 16.5925)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) F_SIG_A_Cu0.face(at (1.73738, -17.4469, 17.3875), at (1.70286, -17.4986, 17.3875), at (1.7752, -17.3976, 17.3875), at (-1.71372, -5.94643, 17.405), at (1.67448, -17.5474, 17.3875), at (1.81617, -17.3509, 17.3875), at (-1.91648, -17.5698, 17.3875), at (1.8601, -17.307, 17.3875), at (-5.49547, -17.379, 17.3875), at (1.90682, -17.266, 17.3875), at (-6.80718, -17.1883, 17.3875), at (1.95611, -17.2282, 17.3875)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) F_SIG_B_Cu0.face(at (-25.6016, -0.907572, 17.3875), at (-26.696, -1.36136, 17.3875), at (-24.4805, -0.480479, 17.3875), at (-27.63, -3.63005, 17.405), at (-29.0926, -1.04104, 17.3875), at (-24.9076, -1.6016, 17.3875), at (-31.1688, -1.53179, 17.3875), at (-25.3614, -2.69602, 17.3875), at (-29.2959, -2.02254, 17.3875), at (-25.041, -5.09259, 17.3875), at (-26.7227, -2.72271, 17.3875), at (-25.5318, -7.16884, 17.3875)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) F_SIG_B_Cu1.face(at (22.3984, -0.907572, 17.3875), at (21.304, -1.36136, 17.3875), at (23.5195, -0.480479, 17.3875), at (20.37, -3.63005, 17.405), at (18.9074, -1.04104, 17.3875), at (23.0924, -1.6016, 17.3875), at (16.8312, -1.53179, 17.3875), at (22.6386, -2.69602, 17.3875), at (18.7041, -2.02254, 17.3875), at (22.959, -5.09259, 17.3875), at (21.2773, -2.72271, 17.3875), at (22.4682, -7.16884, 17.3875)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) F_SIG_B_Cu2.face(at (-22.3025, 10.6016, 17.3875), at (-23.0845, 1.60949, 17.3875), at (-17.2107, 18.8117, 17.3875), at (1.76176, 13.1418, 17.405), at (-23.5195, 0.480479, 17.3875), at (-12.1189, 22.5594, 17.3875), at (-22.3905, 0.915464, 17.3875), at (-9.30718, 26.3071, 17.3875), at (-21.1438, 1.69746, 17.3875), at (-6.49547, 22.5594, 17.3875), at (-20.6791, 2.16216, 17.3875), at (-5.99547, 18.8117, 17.3875)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) Frequency=0GHz Layers{Layer1{Thickness=0.0254um Material=Ouro_vol_nominal} Layer2{Thickness=4.5um Material=NiP_vol_nominal} Layer3{LayerType=1 Thickness=0 Material=Cobre_vol_Groiss}}
  Open1: Radiation Objects=RadiatingSurface
  A: Lumped Port Objects=A_ext LumpedPortType=Modal Modes{Mode1{IntLine{(2.9689184, -18, -33.39) -> (4.0241684, -18, -33.39)} CharImp=Zpi RenormImp=50ohm}} Impedance=50ohm
  B: Lumped Port Objects=B_ext LumpedPortType=Modal Modes{Mode1{IntLine{(2.9689184, 18, -33.39) -> (4.0241684, 18, -33.39)} CharImp=Zpi RenormImp=50ohm}} Impedance=50ohm
mesh:
  initial mesh: MeshMethod=AnsoftClassic
setups:
  Centro: HfssDriven Frequency=5.17GHz MaxDeltaS=0.04 MaximumPasses=6 MinimumPasses=2 MinimumConvergedPasses=2 PercentRefinement=20 BasisOrder=-1 DoLambdaRefine=false PortAccuracy=2 DrivenSolverType="Iterative Solver" IterativeResidual=1e-05 DDMSolverResidual=1e-05 SaveRadFieldsOnly
source amplitudes:
  A:1, B:1: 0.5W 0deg
radiation setups:
  3D: Infinite Sphere Theta=0deg..180deg step 2deg Phi=-180deg..180deg step 2deg
  Elevation: Infinite Sphere Theta=-180deg..180deg step 1deg Phi=0deg..90deg step 90deg
  Azimuth: Infinite Sphere Theta=90deg..90deg step 0deg Phi=-180deg..180deg step 1deg
  HV: Infinite Sphere Theta=-180deg..180deg step 0.25deg Phi=0deg..90deg step 90deg
reports:
  AB_H: dB(RealizedGainTotal), dB(GainTotal), dB(DirTotal), re(rETheta), im(rETheta), re(rEPhi), im(rEPhi) vs Theta on Centro : LastAdaptive, HV [Phi=90deg Freq=5170MHz]
  AB_V: dB(RealizedGainTotal), dB(GainTotal), dB(DirTotal), re(rETheta), im(rETheta), re(rEPhi), im(rEPhi) vs Theta on Centro : LastAdaptive, HV [Phi=0deg Freq=5170MHz]
  A_H: dB(RealizedGainTotal), dB(GainTotal), dB(DirTotal), re(rETheta), im(rETheta), re(rEPhi), im(rEPhi) vs Theta on Centro : LastAdaptive, HV [Phi=90deg Freq=5170MHz]
  A_V: dB(RealizedGainTotal), dB(GainTotal), dB(DirTotal), re(rETheta), im(rETheta), re(rEPhi), im(rEPhi) vs Theta on Centro : LastAdaptive, HV [Phi=0deg Freq=5170MHz]
  B_H: dB(RealizedGainTotal), dB(GainTotal), dB(DirTotal), re(rETheta), im(rETheta), re(rEPhi), im(rEPhi) vs Theta on Centro : LastAdaptive, HV [Phi=90deg Freq=5170MHz]
  B_V: dB(RealizedGainTotal), dB(GainTotal), dB(DirTotal), re(rETheta), im(rETheta), re(rEPhi), im(rEPhi) vs Theta on Centro : LastAdaptive, HV [Phi=0deg Freq=5170MHz]
