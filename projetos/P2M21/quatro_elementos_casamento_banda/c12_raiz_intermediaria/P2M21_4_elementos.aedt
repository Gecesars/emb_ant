# Ansys Electronics Desktop project, version 2024.2
materials:
  vacuum: permittivity=1
  POM_nom: permittivity=3.4 dielectric_loss_tangent=0.01
  PTFE_terminal: permittivity=2.0363635 dielectric_loss_tangent=0.00027683055
  ZYF300: permittivity=2.94 dielectric_loss_tangent=0.0016
  RO4350B_R01: permittivity=3.66 dielectric_loss_tangent=0.0037
  AL5052: conductivity=20000000
  SAC305: conductivity=7575758
  copper: permeability=0.999991 conductivity=58000000
  NiP_vol_nominal: permeability=1 conductivity=1500000
  Ouro_vol_nominal: permeability=1 conductivity=41000000
  Cobre_vol_Groiss: permeability=1 conductivity=28688604

design Quatro_elementos (HFSS, HFSS Hybrid Modal Network, model units mm)
geometry:
  Refletor_Al2mm [AL5052] = imported_body(D:/dev/EMBRAER/P2M21/R13_Casamento_Banda/c12_raiz_intermediaria\cad\AL5052.step)
  PTFE_B, PTFE_A [PTFE_terminal] = imported_body(D:/dev/EMBRAER/P2M21/R13_Casamento_Banda/c12_raiz_intermediaria\cad\PTFE_terminal.step)
  PCB_RO4350B [RO4350B_R01] = imported_body(D:/dev/EMBRAER/P2M21/R13_Casamento_Banda/c12_raiz_intermediaria\cad\RO4350B_R01.step)
  Solda_B, Solda_A [SAC305] = imported_body(D:/dev/EMBRAER/P2M21/R13_Casamento_Banda/c12_raiz_intermediaria\cad\SAC305.step)
  PTH_B, Blindagem_B, Vivo_B, PTH_A, Blindagem_A, Vivo_A, Via_7, Via_6, Via_5, Via_4, Via_3, Via_2, Via_1, Via_0 [copper] = imported_body(D:/dev/EMBRAER/P2M21/R13_Casamento_Banda/c12_raiz_intermediaria\cad\copper.step)
  F_SIG_B_Cu4, F_SIG_B_Cu3, F_SIG_B_Cu2, F_SIG_B_Cu1, F_SIG_B_Cu0, F_SIG_A_Cu0, B_SIG_B_Cu4, B_SIG_B_Cu3, B_SIG_B_Cu2, B_SIG_B_Cu1, B_SIG_B_Cu0, B_SIG_A_Cu0, B_RET_B_Cu0, B_RET_A_Cu0, B_E4_Q3_Cu0, B_E4_Q2_Cu0, B_E3_Q3_Cu0, B_E3_Q2_Cu0, B_E2_Q3_Cu0, B_E2_Q2_Cu0, B_E1_Q3_Cu0, B_E1_Q2_Cu0 [Cobre_vol_Groiss] = imported_body(D:/dev/EMBRAER/P2M21/R13_Casamento_Banda/c12_raiz_intermediaria\cad\folha_cu.step)
  A_ext = circle(normal=Z, centre=(2.5091684mm, -32mm, -35.051mm), radius=1.515mm)
  A_int = circle(normal=Z, centre=(2.5091684mm, -32mm, -35.051mm), radius=0.45975mm)
  A_ext.subtract(A_int)
  B_ext = circle(normal=Z, centre=(2.5091684mm, 32mm, -35.051mm), radius=1.515mm)
  B_int = circle(normal=Z, centre=(2.5091684mm, 32mm, -35.051mm), radius=0.45975mm)
  B_ext.subtract(B_int)
  RadiatingSurface [vacuum] = region(absolute_offset=19.646365mm on all sides)
boundaries and excitations:
  ENIG_faces_expostas: Layered Impedance Faces=B_E1_Q2_Cu0.face(at (-83.0786, 2.59297, 14.9315), at (-77.594, 0.267527, 14.9315), at (-85.404, 6.70202, 14.9315), at (-73.3512, 1.35121, 14.9315), at (-82.9448, 10.9448, 14.9315), at (-72.2675, 5.59403, 14.9315), at (-78.702, 13.404, 14.9315), at (-74.593, 11.0786, 14.9315), at (-75.905, 10.6611, 14.9315), at (-74.4592, 7.16143, 14.9315), at (-75.7834, 3.7834, 14.9315), at (-79.1614, 2.45921, 14.9315)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) B_E1_Q3_Cu0.face(at (-78.6246, -13.2491, 14.9315), at (-74.563, -10.9506, 14.9315), at (-82.8183, -10.8183, 14.9315), at (-72.2644, -5.52938, 14.9315), at (-85.2491, -6.62457, 14.9315), at (-73.3356, -1.3356, 14.9315), at (-82.9506, -2.56301, 14.9315), at (-77.5294, -0.264435, 14.9315), at (-79.0787, -2.43079, 14.9315), at (-75.7397, -3.73968, 14.9315), at (-74.4308, -7.07867, 14.9315), at (-75.8599, -10.5379, 14.9315)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) B_E2_Q2_Cu0.face(at (-35.0786, 2.59297, 14.9315), at (-29.594, 0.267527, 14.9315), at (-37.404, 6.70202, 14.9315), at (-25.3512, 1.35121, 14.9315), at (-34.9448, 10.9448, 14.9315), at (-24.2675, 5.59403, 14.9315), at (-30.702, 13.404, 14.9315), at (-26.593, 11.0786, 14.9315), at (-27.905, 10.6611, 14.9315), at (-26.4592, 7.16143, 14.9315), at (-27.7834, 3.7834, 14.9315), at (-31.1614, 2.45921, 14.9315)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) B_E2_Q3_Cu0.face(at (-30.6246, -13.2491, 14.9315), at (-26.563, -10.9506, 14.9315), at (-34.8183, -10.8183, 14.9315), at (-24.2644, -5.52938, 14.9315), at (-37.2491, -6.62457, 14.9315), at (-25.3356, -1.3356, 14.9315), at (-34.9506, -2.56301, 14.9315), at (-29.5294, -0.264435, 14.9315), at (-31.0787, -2.43079, 14.9315), at (-27.7397, -3.73968, 14.9315), at (-26.4308, -7.07867, 14.9315), at (-27.8599, -10.5379, 14.9315)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) B_E3_Q2_Cu0.face(at (12.9214, 2.59297, 14.9315), at (18.406, 0.267527, 14.9315), at (10.596, 6.70202, 14.9315), at (22.6488, 1.35121, 14.9315), at (13.0552, 10.9448, 14.9315), at (23.7325, 5.59403, 14.9315), at (17.298, 13.404, 14.9315), at (21.407, 11.0786, 14.9315), at (20.095, 10.6611, 14.9315), at (21.5408, 7.16143, 14.9315), at (20.2166, 3.7834, 14.9315), at (16.8386, 2.45921, 14.9315)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) B_E3_Q3_Cu0.face(at (17.3754, -13.2491, 14.9315), at (21.437, -10.9506, 14.9315), at (13.1817, -10.8183, 14.9315), at (23.7356, -5.52938, 14.9315), at (10.7509, -6.62457, 14.9315), at (22.6644, -1.3356, 14.9315), at (13.0494, -2.56301, 14.9315), at (18.4706, -0.264435, 14.9315), at (16.9213, -2.43079, 14.9315), at (20.2603, -3.73968, 14.9315), at (21.5692, -7.07867, 14.9315), at (20.1401, -10.5379, 14.9315)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) B_E4_Q2_Cu0.face(at (60.9214, 2.59297, 14.9315), at (66.406, 0.267527, 14.9315), at (58.596, 6.70202, 14.9315), at (70.6488, 1.35121, 14.9315), at (61.0552, 10.9448, 14.9315), at (71.7325, 5.59403, 14.9315), at (65.298, 13.404, 14.9315), at (69.407, 11.0786, 14.9315), at (68.095, 10.6611, 14.9315), at (69.5408, 7.16143, 14.9315), at (68.2166, 3.7834, 14.9315), at (64.8386, 2.45921, 14.9315)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) B_E4_Q3_Cu0.face(at (65.3754, -13.2491, 14.9315), at (69.437, -10.9506, 14.9315), at (61.1817, -10.8183, 14.9315), at (71.7356, -5.52938, 14.9315), at (58.7509, -6.62457, 14.9315), at (70.6644, -1.3356, 14.9315), at (61.0494, -2.56301, 14.9315), at (66.4706, -0.264435, 14.9315), at (64.9213, -2.43079, 14.9315), at (68.2603, -3.73968, 14.9315), at (69.5692, -7.07867, 14.9315), at (68.1401, -10.5379, 14.9315)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) B_RET_A_Cu0.face(at (23.9356, -5.52938, 14.9315), at (23.934, -8.73638, 14.9315), at (23.7492, -2.13752, 14.9315), at (23.9325, -8.78696, 14.9315), at (23.5648, -1.93751, 14.9315), at (23.7208, -9.04764, 14.9315), at (23.6026, -1.78111, 14.9315), at (23.5092, -15.1296, 14.9315), at (23.6879, -1.49972, 14.9315), at (35.5092, -21, 14.9315), at (23.7922, -1.24558, 14.9315), at (47.5092, -25, 14.9315)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) B_RET_B_Cu0.face(at (-65.4268, 0.264435, 14.9315), at (-61.0494, 2.56301, 14.9315), at (-67.5467, 0.227286, 14.9315), at (-58.7509, 6.62457, 14.9315), at (-67.6484, 0.145069, 14.9315), at (-61.1817, 10.8183, 14.9315), at (-69.3162, 0.1, 14.9315), at (-65.0516, 13.2491, 14.9315), at (-70.6395, 0.383666, 14.9315), at (-66.4908, 14.1246, 14.9315), at (-70.8442, 1.15577, 14.9315), at (-45.4908, 15, 14.9315)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) B_SIG_A_Cu0.face(at (3.30746, -32.0523, 14.9315), at (2.51397, -32, 14.914), at (3.30745, -32.0523, 14.9315), at (3.30917, -32, 14.9315), at (3.30746, -31.9477, 14.9315), at (3.29624, -32.1432, 14.9315), at (3.30745, -31.9477, 14.9315), at (3.29624, -31.8568, 14.9315), at (3.27472, -32.2322, 14.9315), at (3.27472, -32.2322, 14.9315), at (3.27472, -31.7678, 14.9315), at (3.27082, -32.2447, 14.9315)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) B_SIG_B_Cu0.face(at (-73.0143, -1.01434, 14.9315), at (-71.653, -0.347013, 14.9315), at (-72.347, 0.347013, 14.9315), at (-72, 0, 14.914), at (-70.9857, 1.01434, 14.9315), at (-72.9474, -0.747412, 14.9315), at (-71.4526, 0.747412, 14.9315)) B_SIG_B_Cu1.face(at (-25.0143, -1.01434, 14.9315), at (-23.653, -0.347013, 14.9315), at (-24.347, 0.347013, 14.9315), at (-24, 0, 14.914), at (-22.9857, 1.01434, 14.9315), at (-24.9474, -0.747412, 14.9315), at (-23.4526, 0.747412, 14.9315)) B_SIG_B_Cu2.face(at (22.9857, -1.01434, 14.9315), at (24.347, -0.347013, 14.9315), at (23.653, 0.347013, 14.9315), at (24, 0, 14.914), at (25.0143, 1.01434, 14.9315), at (23.0526, -0.747412, 14.9315), at (24.5474, 0.747412, 14.9315)) B_SIG_B_Cu3.face(at (71.653, 0.347013, 14.9315), at (70.9857, -1.01434, 14.9315), at (73.0143, 1.01434, 14.9315), at (72, 0, 14.914), at (72.347, -0.347013, 14.9315), at (71.0526, -0.747412, 14.9315), at (72.5474, 0.747412, 14.9315)) B_SIG_B_Cu4.face(at (3.30746, 31.9477, 14.9315), at (2.51397, 32, 14.914), at (3.30745, 31.9477, 14.9315), at (3.30917, 32, 14.9315), at (3.30746, 32.0523, 14.9315), at (3.29624, 31.8568, 14.9315), at (3.30745, 32.0523, 14.9315), at (3.29624, 32.1432, 14.9315), at (3.27472, 31.7678, 14.9315), at (3.27472, 31.7678, 14.9315), at (3.27472, 32.2322, 14.9315), at (3.27082, 31.7553, 14.9315)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) F_SIG_A_Cu0.face(at (15.9794, -30.3543, 15.7265), at (2.50917, -29.6406, 15.7265), at (22.2756, -31.068, 15.7265), at (-1.42572, -13.6656, 15.744), at (-10.9611, -30.3543, 15.7265), at (28.5717, -30.284, 15.7265), at (-17.2572, -31.068, 15.7265), at (32.0684, -29.5, 15.7265), at (-23.5534, -30.284, 15.7265), at (35.5652, -30.3441, 15.7265), at (-27.0501, -29.5, 15.7265), at (42.6313, -31.1883, 15.7265)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) F_SIG_B_Cu0.face(at (-72.4805, -0.480479, 15.7265), at (-73.6016, -0.907572, 15.7265), at (-72.9076, -1.6016, 15.7265), at (-75.63, -3.63005, 15.744), at (-74.696, -1.36136, 15.7265), at (-73.3614, -2.69602, 15.7265), at (-77.0926, -1.04104, 15.7265), at (-73.041, -5.09259, 15.7265), at (-79.1688, -1.53179, 15.7265), at (-73.5318, -7.16884, 15.7265), at (-77.2959, -2.02254, 15.7265), at (-74.0225, -5.29587, 15.7265)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) F_SIG_B_Cu1.face(at (-24.4805, -0.480479, 15.7265), at (-25.6016, -0.907572, 15.7265), at (-24.9076, -1.6016, 15.7265), at (-27.63, -3.63005, 15.744), at (-26.696, -1.36136, 15.7265), at (-25.3614, -2.69602, 15.7265), at (-29.0926, -1.04104, 15.7265), at (-25.041, -5.09259, 15.7265), at (-31.1688, -1.53179, 15.7265), at (-25.5318, -7.16884, 15.7265), at (-29.2959, -2.02254, 15.7265), at (-26.0225, -5.29587, 15.7265)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) F_SIG_B_Cu2.face(at (23.5195, -0.480479, 15.7265), at (22.3984, -0.907572, 15.7265), at (23.0924, -1.6016, 15.7265), at (20.37, -3.63005, 15.744), at (21.304, -1.36136, 15.7265), at (22.6386, -2.69602, 15.7265), at (18.9074, -1.04104, 15.7265), at (22.959, -5.09259, 15.7265), at (16.8312, -1.53179, 15.7265), at (22.4682, -7.16884, 15.7265), at (18.7041, -2.02254, 15.7265), at (21.9775, -5.29587, 15.7265)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) F_SIG_B_Cu3.face(at (71.5195, -0.480479, 15.7265), at (70.3984, -0.907572, 15.7265), at (71.0924, -1.6016, 15.7265), at (68.37, -3.63005, 15.744), at (69.304, -1.36136, 15.7265), at (70.6386, -2.69602, 15.7265), at (66.9074, -1.04104, 15.7265), at (70.959, -5.09259, 15.7265), at (64.8312, -1.53179, 15.7265), at (70.4682, -7.16884, 15.7265), at (66.7041, -2.02254, 15.7265), at (69.9775, -5.29587, 15.7265)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) F_SIG_B_Cu4.face(at (-68.6791, 2.16216, 15.7265), at (-68.6445, 2.66144, 15.7265), at (-69.1438, 1.69746, 15.7265), at (1.76176, 17.2136, 15.744), at (-68.6445, 2.73061, 15.7265), at (-70.3905, 0.915464, 15.7265), at (-68.6791, 9.97674, 15.7265), at (-71.5195, 0.480479, 15.7265), at (-61.0873, 17.1883, 15.7265), at (-71.0845, 1.60949, 15.7265), at (-53.4955, 17.379, 15.7265), at (-70.3025, 10.6016, 15.7265)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) Frequency=0GHz Layers{Layer1{Thickness=0.0254um Material=Ouro_vol_nominal} Layer2{Thickness=4.5um Material=NiP_vol_nominal} Layer3{LayerType=1 Thickness=0 Material=Cobre_vol_Groiss}}
  Open1: Radiation Objects=RadiatingSurface
  A: Lumped Port Objects=A_ext LumpedPortType=Modal Modes{Mode1{IntLine{(2.9689184, -32, -35.051) -> (4.0241684, -32, -35.051)} CharImp=Zpi RenormImp=50ohm}} Impedance=50ohm
  B: Lumped Port Objects=B_ext LumpedPortType=Modal Modes{Mode1{IntLine{(2.9689184, 32, -35.051) -> (4.0241684, 32, -35.051)} CharImp=Zpi RenormImp=50ohm}} Impedance=50ohm
mesh:
  initial mesh: MeshMethod=AnsoftClassic
setups:
  Centro: HfssDriven Frequency=5.17GHz MaxDeltaS=0.05 MaximumPasses=6 MinimumPasses=6 MinimumConvergedPasses=2 PercentRefinement=75 BasisOrder=2 DoLambdaRefine=false PortAccuracy=2 DrivenSolverType="Iterative Solver" IterativeResidual=1e-05 DDMSolverResidual=1e-05 SaveRadFieldsOnly
    sweep Triagem3: 5090MHz to 5250MHz step 80MHz; Type=Discrete
    sweep Banda_Fast: 5090MHz to 5250MHz step 1MHz; Type=Fast
    sweep Pico_Fast: point 5.173GHz; Type=Discrete
source amplitudes:
  A:1, B:1: 0.5W 0deg
radiation setups:
  3D: Infinite Sphere Theta=0deg..180deg step 2deg Phi=-180deg..180deg step 2deg
  Elevation: Infinite Sphere Theta=-180deg..180deg step 1deg Phi=0deg..90deg step 90deg
  Azimuth: Infinite Sphere Theta=90deg..90deg step 0deg Phi=-180deg..180deg step 1deg
  HV: Infinite Sphere Theta=-180deg..180deg step 0.25deg Phi=0deg..90deg step 90deg
reports:
  AB_H: dB(RealizedGainTotal), dB(GainTotal), dB(DirTotal), re(rETheta), im(rETheta), re(rEPhi), im(rEPhi) vs Theta on Centro : LastAdaptive, HV [Phi=90deg Freq=5170MHz]
  AB_V: dB(RealizedGainTotal), dB(GainTotal), dB(DirTotal), re(rETheta), im(rETheta), re(rEPhi), im(rEPhi) vs Theta on Centro : LastAdaptive, HV [Phi=0deg Freq=5170MHz]
  A_H: dB(RealizedGainTotal), dB(GainTotal), dB(DirTotal), re(rETheta), im(rETheta), re(rEPhi), im(rEPhi) vs Theta on Centro : LastAdaptive, HV [Phi=90deg Freq=5170MHz]
  A_V: dB(RealizedGainTotal), dB(GainTotal), dB(DirTotal), re(rETheta), im(rETheta), re(rEPhi), im(rEPhi) vs Theta on Centro : LastAdaptive, HV [Phi=0deg Freq=5170MHz]
  B_H: dB(RealizedGainTotal), dB(GainTotal), dB(DirTotal), re(rETheta), im(rETheta), re(rEPhi), im(rEPhi) vs Theta on Centro : LastAdaptive, HV [Phi=90deg Freq=5170MHz]
  B_V: dB(RealizedGainTotal), dB(GainTotal), dB(DirTotal), re(rETheta), im(rETheta), re(rEPhi), im(rEPhi) vs Theta on Centro : LastAdaptive, HV [Phi=0deg Freq=5170MHz]
