# Ansys Electronics Desktop project, version 2024.2
materials:
  vacuum: permittivity=1
  POM_nom: permittivity=3.4 dielectric_loss_tangent=0.01
  PTFE_terminal: permittivity=2.0363635 dielectric_loss_tangent=0.00027683055
  ZYF300: permittivity=2.94 dielectric_loss_tangent=0.0016
  RO4350B_R01: permittivity=3.66 dielectric_loss_tangent=0.0037
  AL5052: conductivity=20000000
  SAC305: conductivity=7575758
  copper: permeability=0.999991 conductivity=58000000
  NiP_vol_nominal: permeability=1 conductivity=1500000
  Ouro_vol_nominal: permeability=1 conductivity=41000000
  Cobre_vol_Groiss: permeability=1 conductivity=28688604

design Celulas_4x2 (HFSS, HFSS Hybrid Modal Network, model units mm)
geometry:
  Refletor_Al2mm [AL5052] = imported_body(D:/dev/EMBRAER/P2M21/R16_Oito_Celulas_78mm\cad\AL5052.step)
  C2R4_PTFE_B, C2R4_PTFE_A, C2R3_PTFE_B, C2R3_PTFE_A, C2R2_PTFE_B, C2R2_PTFE_A, C2R1_PTFE_B, C2R1_PTFE_A, C1R4_PTFE_B, C1R4_PTFE_A, C1R3_PTFE_B, C1R3_PTFE_A, C1R2_PTFE_B, C1R2_PTFE_A, C1R1_PTFE_B, C1R1_PTFE_A [PTFE_terminal] = imported_body(D:/dev/EMBRAER/P2M21/R16_Oito_Celulas_78mm\cad\PTFE_terminal.step)
  C2R4_PCB_RO4350B, C2R3_PCB_RO4350B, C2R2_PCB_RO4350B, C2R1_PCB_RO4350B, C1R4_PCB_RO4350B, C1R3_PCB_RO4350B, C1R2_PCB_RO4350B, C1R1_PCB_RO4350B [RO4350B_R01] = imported_body(D:/dev/EMBRAER/P2M21/R16_Oito_Celulas_78mm\cad\RO4350B_R01.step)
  C2R4_Solda_B, C2R4_Solda_A, C2R3_Solda_B, C2R3_Solda_A, C2R2_Solda_B, C2R2_Solda_A, C2R1_Solda_B, C2R1_Solda_A, C1R4_Solda_B, C1R4_Solda_A, C1R3_Solda_B, C1R3_Solda_A, C1R2_Solda_B, C1R2_Solda_A, C1R1_Solda_B, C1R1_Solda_A [SAC305] = imported_body(D:/dev/EMBRAER/P2M21/R16_Oito_Celulas_78mm\cad\SAC305.step)
  C2R4_PTH_B, C2R4_Blindagem_B, C2R4_Vivo_B, C2R4_PTH_A, C2R4_Blindagem_A, C2R4_Vivo_A, C2R4_Via_7, C2R4_Via_6, C2R4_Via_5, C2R4_Via_4, C2R4_Via_3, C2R4_Via_2, C2R4_Via_1, C2R4_Via_0, C2R3_PTH_B, C2R3_Blindagem_B, C2R3_Vivo_B, C2R3_PTH_A, C2R3_Blindagem_A, C2R3_Vivo_A, C2R3_Via_7, C2R3_Via_6, C2R3_Via_5, C2R3_Via_4, C2R3_Via_3, C2R3_Via_2, C2R3_Via_1, C2R3_Via_0, C2R2_PTH_B, C2R2_Blindagem_B, C2R2_Vivo_B, C2R2_PTH_A, C2R2_Blindagem_A, C2R2_Vivo_A, C2R2_Via_7, C2R2_Via_6, C2R2_Via_5, C2R2_Via_4, C2R2_Via_3, C2R2_Via_2, C2R2_Via_1, C2R2_Via_0, C2R1_PTH_B, C2R1_Blindagem_B, C2R1_Vivo_B, C2R1_PTH_A, C2R1_Blindagem_A, C2R1_Vivo_A, C2R1_Via_7, C2R1_Via_6, C2R1_Via_5, C2R1_Via_4, C2R1_Via_3, C2R1_Via_2, C2R1_Via_1, C2R1_Via_0, C1R4_PTH_B, C1R4_Blindagem_B, C1R4_Vivo_B, C1R4_PTH_A, C1R4_Blindagem_A, C1R4_Vivo_A, C1R4_Via_7, C1R4_Via_6, C1R4_Via_5, C1R4_Via_4, C1R4_Via_3, C1R4_Via_2, C1R4_Via_1, C1R4_Via_0, C1R3_PTH_B, C1R3_Blindagem_B, C1R3_Vivo_B, C1R3_PTH_A, C1R3_Blindagem_A, C1R3_Vivo_A, C1R3_Via_7, C1R3_Via_6, C1R3_Via_5, C1R3_Via_4, C1R3_Via_3, C1R3_Via_2, C1R3_Via_1, C1R3_Via_0, C1R2_PTH_B, C1R2_Blindagem_B, C1R2_Vivo_B, C1R2_PTH_A, C1R2_Blindagem_A, C1R2_Vivo_A, C1R2_Via_7, C1R2_Via_6, C1R2_Via_5, C1R2_Via_4, C1R2_Via_3, C1R2_Via_2, C1R2_Via_1, C1R2_Via_0, C1R1_PTH_B, C1R1_Blindagem_B, C1R1_Vivo_B, C1R1_PTH_A, C1R1_Blindagem_A, C1R1_Vivo_A, C1R1_Via_7, C1R1_Via_6, C1R1_Via_5, C1R1_Via_4, C1R1_Via_3, C1R1_Via_2, C1R1_Via_1, C1R1_Via_0 [copper] = imported_body(D:/dev/EMBRAER/P2M21/R16_Oito_Celulas_78mm\cad\copper.step)
  C2R4_F_SIG_B_Cu4, C2R4_F_SIG_B_Cu3, C2R4_F_SIG_B_Cu2, C2R4_F_SIG_B_Cu1, C2R4_F_SIG_B_Cu0, C2R4_F_SIG_A_Cu0, C2R4_B_SIG_B_Cu4, C2R4_B_SIG_B_Cu3, C2R4_B_SIG_B_Cu2, C2R4_B_SIG_B_Cu1, C2R4_B_SIG_B_Cu0, C2R4_B_SIG_A_Cu0, C2R4_B_RET_B_Cu0, C2R4_B_RET_A_Cu0, C2R4_B_E4_Q3_Cu0, C2R4_B_E4_Q2_Cu0, C2R4_B_E3_Q3_Cu0, C2R4_B_E3_Q2_Cu0, C2R4_B_E2_Q3_Cu0, C2R4_B_E2_Q2_Cu0, C2R4_B_E1_Q3_Cu0, C2R4_B_E1_Q2_Cu0, C2R3_F_SIG_B_Cu4, C2R3_F_SIG_B_Cu3, C2R3_F_SIG_B_Cu2, C2R3_F_SIG_B_Cu1, C2R3_F_SIG_B_Cu0, C2R3_F_SIG_A_Cu0, C2R3_B_SIG_B_Cu4, C2R3_B_SIG_B_Cu3, C2R3_B_SIG_B_Cu2, C2R3_B_SIG_B_Cu1, C2R3_B_SIG_B_Cu0, C2R3_B_SIG_A_Cu0, C2R3_B_RET_B_Cu0, C2R3_B_RET_A_Cu0, C2R3_B_E4_Q3_Cu0, C2R3_B_E4_Q2_Cu0, C2R3_B_E3_Q3_Cu0, C2R3_B_E3_Q2_Cu0, C2R3_B_E2_Q3_Cu0, C2R3_B_E2_Q2_Cu0, C2R3_B_E1_Q3_Cu0, C2R3_B_E1_Q2_Cu0, C2R2_F_SIG_B_Cu4, C2R2_F_SIG_B_Cu3, C2R2_F_SIG_B_Cu2, C2R2_F_SIG_B_Cu1, C2R2_F_SIG_B_Cu0, C2R2_F_SIG_A_Cu0, C2R2_B_SIG_B_Cu4, C2R2_B_SIG_B_Cu3, C2R2_B_SIG_B_Cu2, C2R2_B_SIG_B_Cu1, C2R2_B_SIG_B_Cu0, C2R2_B_SIG_A_Cu0, C2R2_B_RET_B_Cu0, C2R2_B_RET_A_Cu0, C2R2_B_E4_Q3_Cu0, C2R2_B_E4_Q2_Cu0, C2R2_B_E3_Q3_Cu0, C2R2_B_E3_Q2_Cu0, C2R2_B_E2_Q3_Cu0, C2R2_B_E2_Q2_Cu0, C2R2_B_E1_Q3_Cu0, C2R2_B_E1_Q2_Cu0, C2R1_F_SIG_B_Cu4, C2R1_F_SIG_B_Cu3, C2R1_F_SIG_B_Cu2, C2R1_F_SIG_B_Cu1, C2R1_F_SIG_B_Cu0, C2R1_F_SIG_A_Cu0, C2R1_B_SIG_B_Cu4, C2R1_B_SIG_B_Cu3, C2R1_B_SIG_B_Cu2, C2R1_B_SIG_B_Cu1, C2R1_B_SIG_B_Cu0, C2R1_B_SIG_A_Cu0, C2R1_B_RET_B_Cu0, C2R1_B_RET_A_Cu0, C2R1_B_E4_Q3_Cu0, C2R1_B_E4_Q2_Cu0, C2R1_B_E3_Q3_Cu0, C2R1_B_E3_Q2_Cu0, C2R1_B_E2_Q3_Cu0, C2R1_B_E2_Q2_Cu0, C2R1_B_E1_Q3_Cu0, C2R1_B_E1_Q2_Cu0, C1R4_F_SIG_B_Cu4, C1R4_F_SIG_B_Cu3, C1R4_F_SIG_B_Cu2, C1R4_F_SIG_B_Cu1, C1R4_F_SIG_B_Cu0, C1R4_F_SIG_A_Cu0, C1R4_B_SIG_B_Cu4, C1R4_B_SIG_B_Cu3, C1R4_B_SIG_B_Cu2, C1R4_B_SIG_B_Cu1, C1R4_B_SIG_B_Cu0, C1R4_B_SIG_A_Cu0, C1R4_B_RET_B_Cu0, C1R4_B_RET_A_Cu0, C1R4_B_E4_Q3_Cu0, C1R4_B_E4_Q2_Cu0, C1R4_B_E3_Q3_Cu0, C1R4_B_E3_Q2_Cu0, C1R4_B_E2_Q3_Cu0, C1R4_B_E2_Q2_Cu0, C1R4_B_E1_Q3_Cu0, C1R4_B_E1_Q2_Cu0, C1R3_F_SIG_B_Cu4, C1R3_F_SIG_B_Cu3, C1R3_F_SIG_B_Cu2, C1R3_F_SIG_B_Cu1, C1R3_F_SIG_B_Cu0, C1R3_F_SIG_A_Cu0, C1R3_B_SIG_B_Cu4, C1R3_B_SIG_B_Cu3, C1R3_B_SIG_B_Cu2, C1R3_B_SIG_B_Cu1, C1R3_B_SIG_B_Cu0, C1R3_B_SIG_A_Cu0, C1R3_B_RET_B_Cu0, C1R3_B_RET_A_Cu0, C1R3_B_E4_Q3_Cu0, C1R3_B_E4_Q2_Cu0, C1R3_B_E3_Q3_Cu0, C1R3_B_E3_Q2_Cu0, C1R3_B_E2_Q3_Cu0, C1R3_B_E2_Q2_Cu0, C1R3_B_E1_Q3_Cu0, C1R3_B_E1_Q2_Cu0, C1R2_F_SIG_B_Cu4, C1R2_F_SIG_B_Cu3, C1R2_F_SIG_B_Cu2, C1R2_F_SIG_B_Cu1, C1R2_F_SIG_B_Cu0, C1R2_F_SIG_A_Cu0, C1R2_B_SIG_B_Cu4, C1R2_B_SIG_B_Cu3, C1R2_B_SIG_B_Cu2, C1R2_B_SIG_B_Cu1, C1R2_B_SIG_B_Cu0, C1R2_B_SIG_A_Cu0, C1R2_B_RET_B_Cu0, C1R2_B_RET_A_Cu0, C1R2_B_E4_Q3_Cu0, C1R2_B_E4_Q2_Cu0, C1R2_B_E3_Q3_Cu0, C1R2_B_E3_Q2_Cu0, C1R2_B_E2_Q3_Cu0, C1R2_B_E2_Q2_Cu0, C1R2_B_E1_Q3_Cu0, C1R2_B_E1_Q2_Cu0, C1R1_F_SIG_B_Cu4, C1R1_F_SIG_B_Cu3, C1R1_F_SIG_B_Cu2, C1R1_F_SIG_B_Cu1, C1R1_F_SIG_B_Cu0, C1R1_F_SIG_A_Cu0, C1R1_B_SIG_B_Cu4, C1R1_B_SIG_B_Cu3, C1R1_B_SIG_B_Cu2, C1R1_B_SIG_B_Cu1, C1R1_B_SIG_B_Cu0, C1R1_B_SIG_A_Cu0, C1R1_B_RET_B_Cu0, C1R1_B_RET_A_Cu0, C1R1_B_E4_Q3_Cu0, C1R1_B_E4_Q2_Cu0, C1R1_B_E3_Q3_Cu0, C1R1_B_E3_Q2_Cu0, C1R1_B_E2_Q3_Cu0, C1R1_B_E2_Q2_Cu0, C1R1_B_E1_Q3_Cu0, C1R1_B_E1_Q2_Cu0 [Cobre_vol_Groiss] = imported_body(D:/dev/EMBRAER/P2M21/R16_Oito_Celulas_78mm\cad\folha_cu.step)
  C1R1_A_ext = circle(normal=Z, centre=(-285.49083mm, -71mm, -35.051mm), radius=1.515mm)
  C1R1_A_int = circle(normal=Z, centre=(-285.49083mm, -71mm, -35.051mm), radius=0.45975mm)
  C1R1_A_ext.subtract(C1R1_A_int)
  C1R1_B_ext = circle(normal=Z, centre=(-285.49083mm, -7mm, -35.051mm), radius=1.515mm)
  C1R1_B_int = circle(normal=Z, centre=(-285.49083mm, -7mm, -35.051mm), radius=0.45975mm)
  C1R1_B_ext.subtract(C1R1_B_int)
  C1R2_A_ext = circle(normal=Z, centre=(-93.490832mm, -71mm, -35.051mm), radius=1.515mm)
  C1R2_A_int = circle(normal=Z, centre=(-93.490832mm, -71mm, -35.051mm), radius=0.45975mm)
  C1R2_A_ext.subtract(C1R2_A_int)
  C1R2_B_ext = circle(normal=Z, centre=(-93.490832mm, -7mm, -35.051mm), radius=1.515mm)
  C1R2_B_int = circle(normal=Z, centre=(-93.490832mm, -7mm, -35.051mm), radius=0.45975mm)
  C1R2_B_ext.subtract(C1R2_B_int)
  C1R3_A_ext = circle(normal=Z, centre=(98.509168mm, -71mm, -35.051mm), radius=1.515mm)
  C1R3_A_int = circle(normal=Z, centre=(98.509168mm, -71mm, -35.051mm), radius=0.45975mm)
  C1R3_A_ext.subtract(C1R3_A_int)
  C1R3_B_ext = circle(normal=Z, centre=(98.509168mm, -7mm, -35.051mm), radius=1.515mm)
  C1R3_B_int = circle(normal=Z, centre=(98.509168mm, -7mm, -35.051mm), radius=0.45975mm)
  C1R3_B_ext.subtract(C1R3_B_int)
  C1R4_A_ext = circle(normal=Z, centre=(290.50917mm, -71mm, -35.051mm), radius=1.515mm)
  C1R4_A_int = circle(normal=Z, centre=(290.50917mm, -71mm, -35.051mm), radius=0.45975mm)
  C1R4_A_ext.subtract(C1R4_A_int)
  C1R4_B_ext = circle(normal=Z, centre=(290.50917mm, -7mm, -35.051mm), radius=1.515mm)
  C1R4_B_int = circle(normal=Z, centre=(290.50917mm, -7mm, -35.051mm), radius=0.45975mm)
  C1R4_B_ext.subtract(C1R4_B_int)
  C2R1_A_ext = circle(normal=Z, centre=(-285.49083mm, 7mm, -35.051mm), radius=1.515mm)
  C2R1_A_int = circle(normal=Z, centre=(-285.49083mm, 7mm, -35.051mm), radius=0.45975mm)
  C2R1_A_ext.subtract(C2R1_A_int)
  C2R1_B_ext = circle(normal=Z, centre=(-285.49083mm, 71mm, -35.051mm), radius=1.515mm)
  C2R1_B_int = circle(normal=Z, centre=(-285.49083mm, 71mm, -35.051mm), radius=0.45975mm)
  C2R1_B_ext.subtract(C2R1_B_int)
  C2R2_A_ext = circle(normal=Z, centre=(-93.490832mm, 7mm, -35.051mm), radius=1.515mm)
  C2R2_A_int = circle(normal=Z, centre=(-93.490832mm, 7mm, -35.051mm), radius=0.45975mm)
  C2R2_A_ext.subtract(C2R2_A_int)
  C2R2_B_ext = circle(normal=Z, centre=(-93.490832mm, 71mm, -35.051mm), radius=1.515mm)
  C2R2_B_int = circle(normal=Z, centre=(-93.490832mm, 71mm, -35.051mm), radius=0.45975mm)
  C2R2_B_ext.subtract(C2R2_B_int)
  C2R3_A_ext = circle(normal=Z, centre=(98.509168mm, 7mm, -35.051mm), radius=1.515mm)
  C2R3_A_int = circle(normal=Z, centre=(98.509168mm, 7mm, -35.051mm), radius=0.45975mm)
  C2R3_A_ext.subtract(C2R3_A_int)
  C2R3_B_ext = circle(normal=Z, centre=(98.509168mm, 71mm, -35.051mm), radius=1.515mm)
  C2R3_B_int = circle(normal=Z, centre=(98.509168mm, 71mm, -35.051mm), radius=0.45975mm)
  C2R3_B_ext.subtract(C2R3_B_int)
  C2R4_A_ext = circle(normal=Z, centre=(290.50917mm, 7mm, -35.051mm), radius=1.515mm)
  C2R4_A_int = circle(normal=Z, centre=(290.50917mm, 7mm, -35.051mm), radius=0.45975mm)
  C2R4_A_ext.subtract(C2R4_A_int)
  C2R4_B_ext = circle(normal=Z, centre=(290.50917mm, 71mm, -35.051mm), radius=1.515mm)
  C2R4_B_int = circle(normal=Z, centre=(290.50917mm, 71mm, -35.051mm), radius=0.45975mm)
  C2R4_B_ext.subtract(C2R4_B_int)
  RadiatingSurface [vacuum] = region(absolute_offset=19.646365mm on all sides)
boundaries and excitations:
  ENIG_faces_expostas: Layered Impedance Faces=C1R1_B_E1_Q2_Cu0.face(at (-371.079, -36.407, 14.9315), at (-365.594, -38.7325, 14.9315), at (-373.404, -32.298, 14.9315), at (-361.351, -37.6488, 14.9315), at (-370.945, -28.0552, 14.9315), at (-360.268, -33.406, 14.9315), at (-366.702, -25.596, 14.9315), at (-362.593, -27.9214, 14.9315), at (-363.905, -28.3389, 14.9315), at (-362.459, -31.8386, 14.9315), at (-363.783, -35.2166, 14.9315), at (-367.161, -36.5408, 14.9315)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) C1R1_B_E1_Q3_Cu0.face(at (-366.625, -52.2491, 14.9315), at (-362.563, -49.9506, 14.9315), at (-370.818, -49.8183, 14.9315), at (-360.264, -44.5294, 14.9315), at (-373.249, -45.6246, 14.9315), at (-361.336, -40.3356, 14.9315), at (-370.951, -41.563, 14.9315), at (-365.529, -39.2644, 14.9315), at (-367.079, -41.4308, 14.9315), at (-363.74, -42.7397, 14.9315), at (-362.431, -46.0787, 14.9315), at (-363.86, -49.5379, 14.9315)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) C1R1_B_E2_Q2_Cu0.face(at (-323.079, -36.407, 14.9315), at (-317.594, -38.7325, 14.9315), at (-325.404, -32.298, 14.9315), at (-313.351, -37.6488, 14.9315), at (-322.945, -28.0552, 14.9315), at (-312.268, -33.406, 14.9315), at (-318.702, -25.596, 14.9315), at (-314.593, -27.9214, 14.9315), at (-315.905, -28.3389, 14.9315), at (-314.459, -31.8386, 14.9315), at (-315.783, -35.2166, 14.9315), at (-319.161, -36.5408, 14.9315)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) C1R1_B_E2_Q3_Cu0.face(at (-318.625, -52.2491, 14.9315), at (-314.563, -49.9506, 14.9315), at (-322.818, -49.8183, 14.9315), at (-312.264, -44.5294, 14.9315), at (-325.249, -45.6246, 14.9315), at (-313.336, -40.3356, 14.9315), at (-322.951, -41.563, 14.9315), at (-317.529, -39.2644, 14.9315), at (-319.079, -41.4308, 14.9315), at (-315.74, -42.7397, 14.9315), at (-314.431, -46.0787, 14.9315), at (-315.86, -49.5379, 14.9315)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) C1R1_B_E3_Q2_Cu0.face(at (-275.079, -36.407, 14.9315), at (-269.594, -38.7325, 14.9315), at (-277.404, -32.298, 14.9315), at (-265.351, -37.6488, 14.9315), at (-274.945, -28.0552, 14.9315), at (-264.268, -33.406, 14.9315), at (-270.702, -25.596, 14.9315), at (-266.593, -27.9214, 14.9315), at (-267.905, -28.3389, 14.9315), at (-266.459, -31.8386, 14.9315), at (-267.783, -35.2166, 14.9315), at (-271.161, -36.5408, 14.9315)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) C1R1_B_E3_Q3_Cu0.face(at (-270.625, -52.2491, 14.9315), at (-266.563, -49.9506, 14.9315), at (-274.818, -49.8183, 14.9315), at (-264.264, -44.5294, 14.9315), at (-277.249, -45.6246, 14.9315), at (-265.336, -40.3356, 14.9315), at (-274.951, -41.563, 14.9315), at (-269.529, -39.2644, 14.9315), at (-271.079, -41.4308, 14.9315), at (-267.74, -42.7397, 14.9315), at (-266.431, -46.0787, 14.9315), at (-267.86, -49.5379, 14.9315)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) C1R1_B_E4_Q2_Cu0.face(at (-227.079, -36.407, 14.9315), at (-221.594, -38.7325, 14.9315), at (-229.404, -32.298, 14.9315), at (-217.351, -37.6488, 14.9315), at (-226.945, -28.0552, 14.9315), at (-216.268, -33.406, 14.9315), at (-222.702, -25.596, 14.9315), at (-218.593, -27.9214, 14.9315), at (-219.905, -28.3389, 14.9315), at (-218.459, -31.8386, 14.9315), at (-219.783, -35.2166, 14.9315), at (-223.161, -36.5408, 14.9315)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) C1R1_B_E4_Q3_Cu0.face(at (-222.625, -52.2491, 14.9315), at (-218.563, -49.9506, 14.9315), at (-226.818, -49.8183, 14.9315), at (-216.264, -44.5294, 14.9315), at (-229.249, -45.6246, 14.9315), at (-217.336, -40.3356, 14.9315), at (-226.951, -41.563, 14.9315), at (-221.529, -39.2644, 14.9315), at (-223.079, -41.4308, 14.9315), at (-219.74, -42.7397, 14.9315), at (-218.431, -46.0787, 14.9315), at (-219.86, -49.5379, 14.9315)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) C1R1_B_RET_A_Cu0.face(at (-264.064, -44.5294, 14.9315), at (-264.066, -47.7364, 14.9315), at (-264.251, -41.1375, 14.9315), at (-264.068, -47.787, 14.9315), at (-264.435, -40.9375, 14.9315), at (-264.279, -48.0476, 14.9315), at (-264.397, -40.7811, 14.9315), at (-264.491, -54.1296, 14.9315), at (-264.312, -40.4997, 14.9315), at (-252.491, -60, 14.9315), at (-264.208, -40.2456, 14.9315), at (-240.491, -64, 14.9315)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) C1R1_B_RET_B_Cu0.face(at (-353.427, -38.7356, 14.9315), at (-349.049, -36.437, 14.9315), at (-355.547, -38.7727, 14.9315), at (-346.751, -32.3754, 14.9315), at (-355.648, -38.8549, 14.9315), at (-349.182, -28.1817, 14.9315), at (-357.316, -38.9, 14.9315), at (-353.052, -25.7509, 14.9315), at (-358.639, -38.6163, 14.9315), at (-354.491, -24.8754, 14.9315), at (-358.844, -37.8442, 14.9315), at (-333.491, -24, 14.9315)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) C1R1_B_SIG_A_Cu0.face(at (-284.693, -71.0523, 14.9315), at (-285.486, -71, 14.914), at (-284.693, -71.0523, 14.9315), at (-284.691, -71, 14.9315), at (-284.693, -70.9477, 14.9315), at (-284.704, -71.1432, 14.9315), at (-284.693, -70.9477, 14.9315), at (-284.704, -70.8568, 14.9315), at (-284.725, -71.2322, 14.9315), at (-284.725, -71.2322, 14.9315), at (-284.725, -70.7678, 14.9315), at (-284.729, -71.2447, 14.9315)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) C1R1_B_SIG_B_Cu0.face(at (-361.014, -40.0143, 14.9315), at (-359.653, -39.347, 14.9315), at (-360.347, -38.653, 14.9315), at (-360, -39, 14.914), at (-358.986, -37.9857, 14.9315), at (-360.947, -39.7474, 14.9315), at (-359.453, -38.2526, 14.9315)) C1R1_B_SIG_B_Cu1.face(at (-313.014, -40.0143, 14.9315), at (-311.653, -39.347, 14.9315), at (-312.347, -38.653, 14.9315), at (-312, -39, 14.914), at (-310.986, -37.9857, 14.9315), at (-312.947, -39.7474, 14.9315), at (-311.453, -38.2526, 14.9315)) C1R1_B_SIG_B_Cu2.face(at (-265.014, -40.0143, 14.9315), at (-263.653, -39.347, 14.9315), at (-264.347, -38.653, 14.9315), at (-264, -39, 14.914), at (-262.986, -37.9857, 14.9315), at (-264.947, -39.7474, 14.9315), at (-263.453, -38.2526, 14.9315)) C1R1_B_SIG_B_Cu3.face(at (-216.347, -38.653, 14.9315), at (-217.014, -40.0143, 14.9315), at (-214.986, -37.9857, 14.9315), at (-216, -39, 14.914), at (-215.653, -39.347, 14.9315), at (-216.947, -39.7474, 14.9315), at (-215.453, -38.2526, 14.9315)) C1R1_B_SIG_B_Cu4.face(at (-284.693, -7.05231, 14.9315), at (-285.486, -7, 14.914), at (-284.693, -7.05234, 14.9315), at (-284.691, -7, 14.9315), at (-284.693, -6.94769, 14.9315), at (-284.704, -7.14322, 14.9315), at (-284.693, -6.94766, 14.9315), at (-284.704, -6.85678, 14.9315), at (-284.725, -7.23222, 14.9315), at (-284.725, -7.23224, 14.9315), at (-284.725, -6.76778, 14.9315), at (-284.729, -7.24472, 14.9315)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) C1R1_F_SIG_A_Cu0.face(at (-272.021, -69.3543, 15.7265), at (-285.491, -68.6406, 15.7265), at (-265.724, -70.068, 15.7265), at (-289.426, -52.6656, 15.744), at (-298.961, -69.3543, 15.7265), at (-259.428, -69.284, 15.7265), at (-305.257, -70.068, 15.7265), at (-255.932, -68.5, 15.7265), at (-311.553, -69.284, 15.7265), at (-252.435, -69.3441, 15.7265), at (-315.05, -68.5, 15.7265), at (-245.369, -70.1883, 15.7265)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) C1R1_F_SIG_B_Cu0.face(at (-360.48, -39.4805, 15.7265), at (-361.602, -39.9076, 15.7265), at (-360.908, -40.6016, 15.7265), at (-363.63, -42.63, 15.744), at (-362.696, -40.3614, 15.7265), at (-361.361, -41.696, 15.7265), at (-365.093, -40.041, 15.7265), at (-361.041, -44.0926, 15.7265), at (-367.169, -40.5318, 15.7265), at (-361.532, -46.1688, 15.7265), at (-365.296, -41.0225, 15.7265), at (-362.023, -44.2959, 15.7265)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) C1R1_F_SIG_B_Cu1.face(at (-312.48, -39.4805, 15.7265), at (-313.602, -39.9076, 15.7265), at (-312.908, -40.6016, 15.7265), at (-315.63, -42.63, 15.744), at (-314.696, -40.3614, 15.7265), at (-313.361, -41.696, 15.7265), at (-317.093, -40.041, 15.7265), at (-313.041, -44.0926, 15.7265), at (-319.169, -40.5318, 15.7265), at (-313.532, -46.1688, 15.7265), at (-317.296, -41.0225, 15.7265), at (-314.023, -44.2959, 15.7265)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) C1R1_F_SIG_B_Cu2.face(at (-264.48, -39.4805, 15.7265), at (-265.602, -39.9076, 15.7265), at (-264.908, -40.6016, 15.7265), at (-267.63, -42.63, 15.744), at (-266.696, -40.3614, 15.7265), at (-265.361, -41.696, 15.7265), at (-269.093, -40.041, 15.7265), at (-265.041, -44.0926, 15.7265), at (-271.169, -40.5318, 15.7265), at (-265.532, -46.1688, 15.7265), at (-269.296, -41.0225, 15.7265), at (-266.023, -44.2959, 15.7265)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) C1R1_F_SIG_B_Cu3.face(at (-216.48, -39.4805, 15.7265), at (-217.602, -39.9076, 15.7265), at (-216.908, -40.6016, 15.7265), at (-219.63, -42.63, 15.744), at (-218.696, -40.3614, 15.7265), at (-217.361, -41.696, 15.7265), at (-221.093, -40.041, 15.7265), at (-217.041, -44.0926, 15.7265), at (-223.169, -40.5318, 15.7265), at (-217.532, -46.1688, 15.7265), at (-221.296, -41.0225, 15.7265), at (-218.023, -44.2959, 15.7265)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) C1R1_F_SIG_B_Cu4.face(at (-356.679, -36.8378, 15.7265), at (-356.645, -36.3386, 15.7265), at (-357.144, -37.3025, 15.7265), at (-286.238, -21.7864, 15.744), at (-356.645, -36.2694, 15.7265), at (-358.391, -38.0845, 15.7265), at (-356.679, -29.0233, 15.7265), at (-359.52, -38.5195, 15.7265), at (-349.087, -21.8117, 15.7265), at (-359.085, -37.3905, 15.7265), at (-341.495, -21.621, 15.7265), at (-358.303, -28.3984, 15.7265)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) C1R2_B_E1_Q2_Cu0.face(at (-179.079, -36.407, 14.9315), at (-173.594, -38.7325, 14.9315), at (-181.404, -32.298, 14.9315), at (-169.351, -37.6488, 14.9315), at (-178.945, -28.0552, 14.9315), at (-168.268, -33.406, 14.9315), at (-174.702, -25.596, 14.9315), at (-170.593, -27.9214, 14.9315), at (-171.905, -28.3389, 14.9315), at (-170.459, -31.8386, 14.9315), at (-171.783, -35.2166, 14.9315), at (-175.161, -36.5408, 14.9315)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) C1R2_B_E1_Q3_Cu0.face(at (-174.625, -52.2491, 14.9315), at (-170.563, -49.9506, 14.9315), at (-178.818, -49.8183, 14.9315), at (-168.264, -44.5294, 14.9315), at (-181.249, -45.6246, 14.9315), at (-169.336, -40.3356, 14.9315), at (-178.951, -41.563, 14.9315), at (-173.529, -39.2644, 14.9315), at (-175.079, -41.4308, 14.9315), at (-171.74, -42.7397, 14.9315), at (-170.431, -46.0787, 14.9315), at (-171.86, -49.5379, 14.9315)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) C1R2_B_E2_Q2_Cu0.face(at (-131.079, -36.407, 14.9315), at (-125.594, -38.7325, 14.9315), at (-133.404, -32.298, 14.9315), at (-121.351, -37.6488, 14.9315), at (-130.945, -28.0552, 14.9315), at (-120.268, -33.406, 14.9315), at (-126.702, -25.596, 14.9315), at (-122.593, -27.9214, 14.9315), at (-123.905, -28.3389, 14.9315), at (-122.459, -31.8386, 14.9315), at (-123.783, -35.2166, 14.9315), at (-127.161, -36.5408, 14.9315)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) C1R2_B_E2_Q3_Cu0.face(at (-126.625, -52.2491, 14.9315), at (-122.563, -49.9506, 14.9315), at (-130.818, -49.8183, 14.9315), at (-120.264, -44.5294, 14.9315), at (-133.249, -45.6246, 14.9315), at (-121.336, -40.3356, 14.9315), at (-130.951, -41.563, 14.9315), at (-125.529, -39.2644, 14.9315), at (-127.079, -41.4308, 14.9315), at (-123.74, -42.7397, 14.9315), at (-122.431, -46.0787, 14.9315), at (-123.86, -49.5379, 14.9315)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) C1R2_B_E3_Q2_Cu0.face(at (-83.0786, -36.407, 14.9315), at (-77.594, -38.7325, 14.9315), at (-85.404, -32.298, 14.9315), at (-73.3512, -37.6488, 14.9315), at (-82.9448, -28.0552, 14.9315), at (-72.2675, -33.406, 14.9315), at (-78.702, -25.596, 14.9315), at (-74.593, -27.9214, 14.9315), at (-75.905, -28.3389, 14.9315), at (-74.4592, -31.8386, 14.9315), at (-75.7834, -35.2166, 14.9315), at (-79.1614, -36.5408, 14.9315)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) C1R2_B_E3_Q3_Cu0.face(at (-78.6246, -52.2491, 14.9315), at (-74.563, -49.9506, 14.9315), at (-82.8183, -49.8183, 14.9315), at (-72.2644, -44.5294, 14.9315), at (-85.2491, -45.6246, 14.9315), at (-73.3356, -40.3356, 14.9315), at (-82.9506, -41.563, 14.9315), at (-77.5294, -39.2644, 14.9315), at (-79.0787, -41.4308, 14.9315), at (-75.7397, -42.7397, 14.9315), at (-74.4308, -46.0787, 14.9315), at (-75.8599, -49.5379, 14.9315)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) C1R2_B_E4_Q2_Cu0.face(at (-35.0786, -36.407, 14.9315), at (-29.594, -38.7325, 14.9315), at (-37.404, -32.298, 14.9315), at (-25.3512, -37.6488, 14.9315), at (-34.9448, -28.0552, 14.9315), at (-24.2675, -33.406, 14.9315), at (-30.702, -25.596, 14.9315), at (-26.593, -27.9214, 14.9315), at (-27.905, -28.3389, 14.9315), at (-26.4592, -31.8386, 14.9315), at (-27.7834, -35.2166, 14.9315), at (-31.1614, -36.5408, 14.9315)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) C1R2_B_E4_Q3_Cu0.face(at (-30.6246, -52.2491, 14.9315), at (-26.563, -49.9506, 14.9315), at (-34.8183, -49.8183, 14.9315), at (-24.2644, -44.5294, 14.9315), at (-37.2491, -45.6246, 14.9315), at (-25.3356, -40.3356, 14.9315), at (-34.9506, -41.563, 14.9315), at (-29.5294, -39.2644, 14.9315), at (-31.0787, -41.4308, 14.9315), at (-27.7397, -42.7397, 14.9315), at (-26.4308, -46.0787, 14.9315), at (-27.8599, -49.5379, 14.9315)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) C1R2_B_RET_A_Cu0.face(at (-72.0644, -44.5294, 14.9315), at (-72.066, -47.7364, 14.9315), at (-72.2508, -41.1375, 14.9315), at (-72.0675, -47.787, 14.9315), at (-72.4352, -40.9375, 14.9315), at (-72.2792, -48.0476, 14.9315), at (-72.3974, -40.7811, 14.9315), at (-72.4908, -54.1296, 14.9315), at (-72.3121, -40.4997, 14.9315), at (-60.4908, -60, 14.9315), at (-72.2078, -40.2456, 14.9315), at (-48.4908, -64, 14.9315)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) C1R2_B_RET_B_Cu0.face(at (-161.427, -38.7356, 14.9315), at (-157.049, -36.437, 14.9315), at (-163.547, -38.7727, 14.9315), at (-154.751, -32.3754, 14.9315), at (-163.648, -38.8549, 14.9315), at (-157.182, -28.1817, 14.9315), at (-165.316, -38.9, 14.9315), at (-161.052, -25.7509, 14.9315), at (-166.639, -38.6163, 14.9315), at (-162.491, -24.8754, 14.9315), at (-166.844, -37.8442, 14.9315), at (-141.491, -24, 14.9315)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) C1R2_B_SIG_A_Cu0.face(at (-92.6925, -71.0523, 14.9315), at (-93.486, -71, 14.914), at (-92.6925, -71.0523, 14.9315), at (-92.6908, -71, 14.9315), at (-92.6925, -70.9477, 14.9315), at (-92.7038, -71.1432, 14.9315), at (-92.6925, -70.9477, 14.9315), at (-92.7038, -70.8568, 14.9315), at (-92.7253, -71.2322, 14.9315), at (-92.7253, -71.2322, 14.9315), at (-92.7253, -70.7678, 14.9315), at (-92.7292, -71.2447, 14.9315)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) C1R2_B_SIG_B_Cu0.face(at (-169.014, -40.0143, 14.9315), at (-167.653, -39.347, 14.9315), at (-168.347, -38.653, 14.9315), at (-168, -39, 14.914), at (-166.986, -37.9857, 14.9315), at (-168.947, -39.7474, 14.9315), at (-167.453, -38.2526, 14.9315)) C1R2_B_SIG_B_Cu1.face(at (-121.014, -40.0143, 14.9315), at (-119.653, -39.347, 14.9315), at (-120.347, -38.653, 14.9315), at (-120, -39, 14.914), at (-118.986, -37.9857, 14.9315), at (-120.947, -39.7474, 14.9315), at (-119.453, -38.2526, 14.9315)) C1R2_B_SIG_B_Cu2.face(at (-73.0143, -40.0143, 14.9315), at (-71.653, -39.347, 14.9315), at (-72.347, -38.653, 14.9315), at (-72, -39, 14.914), at (-70.9857, -37.9857, 14.9315), at (-72.9474, -39.7474, 14.9315), at (-71.4526, -38.2526, 14.9315)) C1R2_B_SIG_B_Cu3.face(at (-24.347, -38.653, 14.9315), at (-25.0143, -40.0143, 14.9315), at (-22.9857, -37.9857, 14.9315), at (-24, -39, 14.914), at (-23.653, -39.347, 14.9315), at (-24.9474, -39.7474, 14.9315), at (-23.4526, -38.2526, 14.9315)) C1R2_B_SIG_B_Cu4.face(at (-92.6925, -7.05231, 14.9315), at (-93.486, -7, 14.914), at (-92.6925, -7.05234, 14.9315), at (-92.6908, -7, 14.9315), at (-92.6925, -6.94769, 14.9315), at (-92.7038, -7.14322, 14.9315), at (-92.6925, -6.94766, 14.9315), at (-92.7038, -6.85678, 14.9315), at (-92.7253, -7.23222, 14.9315), at (-92.7253, -7.23224, 14.9315), at (-92.7253, -6.76778, 14.9315), at (-92.7292, -7.24472, 14.9315)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) C1R2_F_SIG_A_Cu0.face(at (-80.0206, -69.3543, 15.7265), at (-93.4908, -68.6406, 15.7265), at (-73.7244, -70.068, 15.7265), at (-97.4257, -52.6656, 15.744), at (-106.961, -69.3543, 15.7265), at (-67.4283, -69.284, 15.7265), at (-113.257, -70.068, 15.7265), at (-63.9316, -68.5, 15.7265), at (-119.553, -69.284, 15.7265), at (-60.4348, -69.3441, 15.7265), at (-123.05, -68.5, 15.7265), at (-53.3687, -70.1883, 15.7265)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) C1R2_F_SIG_B_Cu0.face(at (-168.48, -39.4805, 15.7265), at (-169.602, -39.9076, 15.7265), at (-168.908, -40.6016, 15.7265), at (-171.63, -42.63, 15.744), at (-170.696, -40.3614, 15.7265), at (-169.361, -41.696, 15.7265), at (-173.093, -40.041, 15.7265), at (-169.041, -44.0926, 15.7265), at (-175.169, -40.5318, 15.7265), at (-169.532, -46.1688, 15.7265), at (-173.296, -41.0225, 15.7265), at (-170.023, -44.2959, 15.7265)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)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 Frequency=0GHz Layers{Layer1{Thickness=0.0254um Material=Ouro_vol_nominal} Layer2{Thickness=4.5um Material=NiP_vol_nominal} Layer3{LayerType=1 Thickness=0 Material=Cobre_vol_Groiss}}
  Open1: Radiation Objects=RadiatingSurface
  C1R1_A: Lumped Port Objects=C1R1_A_ext LumpedPortType=Modal Modes{Mode1{IntLine{(-285.03108, -71, -35.051) -> (-283.97583, -71, -35.051)} CharImp=Zpi RenormImp=50ohm}} Impedance=50ohm
  C1R1_B: Lumped Port Objects=C1R1_B_ext LumpedPortType=Modal Modes{Mode1{IntLine{(-285.03108, -7, -35.051) -> (-283.97583, -7, -35.051)} CharImp=Zpi RenormImp=50ohm}} Impedance=50ohm
  C1R2_A: Lumped Port Objects=C1R2_A_ext LumpedPortType=Modal Modes{Mode1{IntLine{(-93.031082, -71, -35.051) -> (-91.975832, -71, -35.051)} CharImp=Zpi RenormImp=50ohm}} Impedance=50ohm
  C1R2_B: Lumped Port Objects=C1R2_B_ext LumpedPortType=Modal Modes{Mode1{IntLine{(-93.031082, -7, -35.051) -> (-91.975832, -7, -35.051)} CharImp=Zpi RenormImp=50ohm}} Impedance=50ohm
  C1R3_A: Lumped Port Objects=C1R3_A_ext LumpedPortType=Modal Modes{Mode1{IntLine{(98.968918, -71, -35.051) -> (100.02417, -71, -35.051)} CharImp=Zpi RenormImp=50ohm}} Impedance=50ohm
  C1R3_B: Lumped Port Objects=C1R3_B_ext LumpedPortType=Modal Modes{Mode1{IntLine{(98.968918, -7, -35.051) -> (100.02417, -7, -35.051)} CharImp=Zpi RenormImp=50ohm}} Impedance=50ohm
  C1R4_A: Lumped Port Objects=C1R4_A_ext LumpedPortType=Modal Modes{Mode1{IntLine{(290.96892, -71, -35.051) -> (292.02417, -71, -35.051)} CharImp=Zpi RenormImp=50ohm}} Impedance=50ohm
  C1R4_B: Lumped Port Objects=C1R4_B_ext LumpedPortType=Modal Modes{Mode1{IntLine{(290.96892, -7, -35.051) -> (292.02417, -7, -35.051)} CharImp=Zpi RenormImp=50ohm}} Impedance=50ohm
  C2R1_A: Lumped Port Objects=C2R1_A_ext LumpedPortType=Modal Modes{Mode1{IntLine{(-285.03108, 7, -35.051) -> (-283.97583, 7, -35.051)} CharImp=Zpi RenormImp=50ohm}} Impedance=50ohm
  C2R1_B: Lumped Port Objects=C2R1_B_ext LumpedPortType=Modal Modes{Mode1{IntLine{(-285.03108, 71, -35.051) -> (-283.97583, 71, -35.051)} CharImp=Zpi RenormImp=50ohm}} Impedance=50ohm
  C2R2_A: Lumped Port Objects=C2R2_A_ext LumpedPortType=Modal Modes{Mode1{IntLine{(-93.031082, 7, -35.051) -> (-91.975832, 7, -35.051)} CharImp=Zpi RenormImp=50ohm}} Impedance=50ohm
  C2R2_B: Lumped Port Objects=C2R2_B_ext LumpedPortType=Modal Modes{Mode1{IntLine{(-93.031082, 71, -35.051) -> (-91.975832, 71, -35.051)} CharImp=Zpi RenormImp=50ohm}} Impedance=50ohm
  C2R3_A: Lumped Port Objects=C2R3_A_ext LumpedPortType=Modal Modes{Mode1{IntLine{(98.968918, 7, -35.051) -> (100.02417, 7, -35.051)} CharImp=Zpi RenormImp=50ohm}} Impedance=50ohm
  C2R3_B: Lumped Port Objects=C2R3_B_ext LumpedPortType=Modal Modes{Mode1{IntLine{(98.968918, 71, -35.051) -> (100.02417, 71, -35.051)} CharImp=Zpi RenormImp=50ohm}} Impedance=50ohm
  C2R4_A: Lumped Port Objects=C2R4_A_ext LumpedPortType=Modal Modes{Mode1{IntLine{(290.96892, 7, -35.051) -> (292.02417, 7, -35.051)} CharImp=Zpi RenormImp=50ohm}} Impedance=50ohm
  C2R4_B: Lumped Port Objects=C2R4_B_ext LumpedPortType=Modal Modes{Mode1{IntLine{(290.96892, 71, -35.051) -> (292.02417, 71, -35.051)} CharImp=Zpi RenormImp=50ohm}} Impedance=50ohm
mesh:
  initial mesh: MeshMethod=AnsoftClassic
setups:
  Centro: HfssDriven Frequency=5.17GHz MaxDeltaS=0.05 MaximumPasses=6 MinimumPasses=2 MinimumConvergedPasses=2 PercentRefinement=20 BasisOrder=1 DoLambdaRefine=false PortAccuracy=2 DrivenSolverType="Iterative Solver" IterativeResidual=1e-05 DDMSolverResidual=1e-05 SaveRadFieldsOnly ExpressionCache{CacheItem{Title=R14_Campo_00 Expression=dB(RealizedGainTotal) Intrinsics="Phi='90deg' Theta='0deg'" TraceID=145 ReportType=3} CacheItem{Title=R14_Campo_01 Expression=dB(RealizedGainTotal) Intrinsics="Phi='90deg' Theta='-10deg'" TraceID=146 ReportType=3} CacheItem{Title=R14_Campo_02 Expression=dB(RealizedGainTotal) Intrinsics="Phi='90deg' Theta='10deg'" TraceID=147 ReportType=3} CacheItem{Title=R14_Campo_03 Expression=dB(RealizedGainTotal) Intrinsics="Phi='90deg' Theta='-54deg'" TraceID=148 ReportType=3} CacheItem{Title=R14_Campo_04 Expression=dB(RealizedGainTotal) Intrinsics="Phi='90deg' Theta='54deg'" TraceID=149 ReportType=3} CacheItem{Title=R14_Campo_05 Expression=dB(RealizedGainTotal) Intrinsics="Phi='0deg' Theta='-1.75deg'" TraceID=150 ReportType=3} CacheItem{Title=R14_Campo_06 Expression=dB(RealizedGainTotal) Intrinsics="Phi='0deg' Theta='1.75deg'" TraceID=151 ReportType=3} CacheItem{Title=R14_Campo_07 Expression=dB(RealizedGainTotal) Intrinsics="Phi='0deg' Theta='-45deg'" TraceID=152 ReportType=3} CacheItem{Title=R14_Campo_08 Expression=dB(RealizedGainTotal) Intrinsics="Phi='0deg' Theta='45deg'" TraceID=153 ReportType=3}}
source amplitudes:
  C1R1_A:1, C1R1_B:1, C1R2_A:1, C1R2_B:1, C1R3_A:1, C1R3_B:1, C1R4_A:1, C1R4_B:1, C2R1_A:1, C2R1_B:1, C2R2_A:1, C2R2_B:1, C2R3_A:1, C2R3_B:1, C2R4_A:1, C2R4_B:1: 0.0625W 0deg
radiation setups:
  3D: Infinite Sphere Theta=0deg..180deg step 2deg Phi=-180deg..180deg step 2deg
  Elevation: Infinite Sphere Theta=-180deg..180deg step 1deg Phi=0deg..90deg step 90deg
  Azimuth: Infinite Sphere Theta=90deg..90deg step 0deg Phi=-180deg..180deg step 1deg
  HV: Infinite Sphere Theta=-180deg..180deg step 0.25deg Phi=0deg..90deg step 90deg
reports:
  ALL_H: dB(RealizedGainTotal), dB(GainTotal), dB(DirTotal), re(rETheta), im(rETheta), re(rEPhi), im(rEPhi) vs Theta on Centro : LastAdaptive, HV [Phi=90deg Freq=5170MHz]
  ALL_V: dB(RealizedGainTotal), dB(GainTotal), dB(DirTotal), re(rETheta), im(rETheta), re(rEPhi), im(rEPhi) vs Theta on Centro : LastAdaptive, HV [Phi=0deg Freq=5170MHz]
  POL_A_H: dB(RealizedGainTotal), dB(GainTotal), dB(DirTotal), re(rETheta), im(rETheta), re(rEPhi), im(rEPhi) vs Theta on Centro : LastAdaptive, HV [Phi=90deg Freq=5170MHz]
  POL_A_V: dB(RealizedGainTotal), dB(GainTotal), dB(DirTotal), re(rETheta), im(rETheta), re(rEPhi), im(rEPhi) vs Theta on Centro : LastAdaptive, HV [Phi=0deg Freq=5170MHz]
  POL_B_H: dB(RealizedGainTotal), dB(GainTotal), dB(DirTotal), re(rETheta), im(rETheta), re(rEPhi), im(rEPhi) vs Theta on Centro : LastAdaptive, HV [Phi=90deg Freq=5170MHz]
  POL_B_V: dB(RealizedGainTotal), dB(GainTotal), dB(DirTotal), re(rETheta), im(rETheta), re(rEPhi), im(rEPhi) vs Theta on Centro : LastAdaptive, HV [Phi=0deg Freq=5170MHz]
  C1R1_A_H: dB(RealizedGainTotal), dB(GainTotal), dB(DirTotal), re(rETheta), im(rETheta), re(rEPhi), im(rEPhi) vs Theta on Centro : LastAdaptive, HV [Phi=90deg Freq=5170MHz]
  C1R1_A_V: dB(RealizedGainTotal), dB(GainTotal), dB(DirTotal), re(rETheta), im(rETheta), re(rEPhi), im(rEPhi) vs Theta on Centro : LastAdaptive, HV [Phi=0deg Freq=5170MHz]
  C1R1_B_H: dB(RealizedGainTotal), dB(GainTotal), dB(DirTotal), re(rETheta), im(rETheta), re(rEPhi), im(rEPhi) vs Theta on Centro : LastAdaptive, HV [Phi=90deg Freq=5170MHz]
  C1R1_B_V: dB(RealizedGainTotal), dB(GainTotal), dB(DirTotal), re(rETheta), im(rETheta), re(rEPhi), im(rEPhi) vs Theta on Centro : LastAdaptive, HV [Phi=0deg Freq=5170MHz]
  C1R2_A_H: dB(RealizedGainTotal), dB(GainTotal), dB(DirTotal), re(rETheta), im(rETheta), re(rEPhi), im(rEPhi) vs Theta on Centro : LastAdaptive, HV [Phi=90deg Freq=5170MHz]
  C1R2_A_V: dB(RealizedGainTotal), dB(GainTotal), dB(DirTotal), re(rETheta), im(rETheta), re(rEPhi), im(rEPhi) vs Theta on Centro : LastAdaptive, HV [Phi=0deg Freq=5170MHz]
  C1R2_B_H: dB(RealizedGainTotal), dB(GainTotal), dB(DirTotal), re(rETheta), im(rETheta), re(rEPhi), im(rEPhi) vs Theta on Centro : LastAdaptive, HV [Phi=90deg Freq=5170MHz]
  C1R2_B_V: dB(RealizedGainTotal), dB(GainTotal), dB(DirTotal), re(rETheta), im(rETheta), re(rEPhi), im(rEPhi) vs Theta on Centro : LastAdaptive, HV [Phi=0deg Freq=5170MHz]
  C1R3_A_H: dB(RealizedGainTotal), dB(GainTotal), dB(DirTotal), re(rETheta), im(rETheta), re(rEPhi), im(rEPhi) vs Theta on Centro : LastAdaptive, HV [Phi=90deg Freq=5170MHz]
  C1R3_A_V: dB(RealizedGainTotal), dB(GainTotal), dB(DirTotal), re(rETheta), im(rETheta), re(rEPhi), im(rEPhi) vs Theta on Centro : LastAdaptive, HV [Phi=0deg Freq=5170MHz]
  C1R3_B_H: dB(RealizedGainTotal), dB(GainTotal), dB(DirTotal), re(rETheta), im(rETheta), re(rEPhi), im(rEPhi) vs Theta on Centro : LastAdaptive, HV [Phi=90deg Freq=5170MHz]
  C1R3_B_V: dB(RealizedGainTotal), dB(GainTotal), dB(DirTotal), re(rETheta), im(rETheta), re(rEPhi), im(rEPhi) vs Theta on Centro : LastAdaptive, HV [Phi=0deg Freq=5170MHz]
  C1R4_A_H: dB(RealizedGainTotal), dB(GainTotal), dB(DirTotal), re(rETheta), im(rETheta), re(rEPhi), im(rEPhi) vs Theta on Centro : LastAdaptive, HV [Phi=90deg Freq=5170MHz]
  C1R4_A_V: dB(RealizedGainTotal), dB(GainTotal), dB(DirTotal), re(rETheta), im(rETheta), re(rEPhi), im(rEPhi) vs Theta on Centro : LastAdaptive, HV [Phi=0deg Freq=5170MHz]
  C1R4_B_H: dB(RealizedGainTotal), dB(GainTotal), dB(DirTotal), re(rETheta), im(rETheta), re(rEPhi), im(rEPhi) vs Theta on Centro : LastAdaptive, HV [Phi=90deg Freq=5170MHz]
  C1R4_B_V: dB(RealizedGainTotal), dB(GainTotal), dB(DirTotal), re(rETheta), im(rETheta), re(rEPhi), im(rEPhi) vs Theta on Centro : LastAdaptive, HV [Phi=0deg Freq=5170MHz]
  C2R1_A_H: dB(RealizedGainTotal), dB(GainTotal), dB(DirTotal), re(rETheta), im(rETheta), re(rEPhi), im(rEPhi) vs Theta on Centro : LastAdaptive, HV [Phi=90deg Freq=5170MHz]
  C2R1_A_V: dB(RealizedGainTotal), dB(GainTotal), dB(DirTotal), re(rETheta), im(rETheta), re(rEPhi), im(rEPhi) vs Theta on Centro : LastAdaptive, HV [Phi=0deg Freq=5170MHz]
  C2R1_B_H: dB(RealizedGainTotal), dB(GainTotal), dB(DirTotal), re(rETheta), im(rETheta), re(rEPhi), im(rEPhi) vs Theta on Centro : LastAdaptive, HV [Phi=90deg Freq=5170MHz]
  C2R1_B_V: dB(RealizedGainTotal), dB(GainTotal), dB(DirTotal), re(rETheta), im(rETheta), re(rEPhi), im(rEPhi) vs Theta on Centro : LastAdaptive, HV [Phi=0deg Freq=5170MHz]
  C2R2_A_H: dB(RealizedGainTotal), dB(GainTotal), dB(DirTotal), re(rETheta), im(rETheta), re(rEPhi), im(rEPhi) vs Theta on Centro : LastAdaptive, HV [Phi=90deg Freq=5170MHz]
  C2R2_A_V: dB(RealizedGainTotal), dB(GainTotal), dB(DirTotal), re(rETheta), im(rETheta), re(rEPhi), im(rEPhi) vs Theta on Centro : LastAdaptive, HV [Phi=0deg Freq=5170MHz]
  C2R2_B_H: dB(RealizedGainTotal), dB(GainTotal), dB(DirTotal), re(rETheta), im(rETheta), re(rEPhi), im(rEPhi) vs Theta on Centro : LastAdaptive, HV [Phi=90deg Freq=5170MHz]
  C2R2_B_V: dB(RealizedGainTotal), dB(GainTotal), dB(DirTotal), re(rETheta), im(rETheta), re(rEPhi), im(rEPhi) vs Theta on Centro : LastAdaptive, HV [Phi=0deg Freq=5170MHz]
  C2R3_A_H: dB(RealizedGainTotal), dB(GainTotal), dB(DirTotal), re(rETheta), im(rETheta), re(rEPhi), im(rEPhi) vs Theta on Centro : LastAdaptive, HV [Phi=90deg Freq=5170MHz]
  C2R3_A_V: dB(RealizedGainTotal), dB(GainTotal), dB(DirTotal), re(rETheta), im(rETheta), re(rEPhi), im(rEPhi) vs Theta on Centro : LastAdaptive, HV [Phi=0deg Freq=5170MHz]
  C2R3_B_H: dB(RealizedGainTotal), dB(GainTotal), dB(DirTotal), re(rETheta), im(rETheta), re(rEPhi), im(rEPhi) vs Theta on Centro : LastAdaptive, HV [Phi=90deg Freq=5170MHz]
  C2R3_B_V: dB(RealizedGainTotal), dB(GainTotal), dB(DirTotal), re(rETheta), im(rETheta), re(rEPhi), im(rEPhi) vs Theta on Centro : LastAdaptive, HV [Phi=0deg Freq=5170MHz]
  C2R4_A_H: dB(RealizedGainTotal), dB(GainTotal), dB(DirTotal), re(rETheta), im(rETheta), re(rEPhi), im(rEPhi) vs Theta on Centro : LastAdaptive, HV [Phi=90deg Freq=5170MHz]
  C2R4_A_V: dB(RealizedGainTotal), dB(GainTotal), dB(DirTotal), re(rETheta), im(rETheta), re(rEPhi), im(rEPhi) vs Theta on Centro : LastAdaptive, HV [Phi=0deg Freq=5170MHz]
  C2R4_B_H: dB(RealizedGainTotal), dB(GainTotal), dB(DirTotal), re(rETheta), im(rETheta), re(rEPhi), im(rEPhi) vs Theta on Centro : LastAdaptive, HV [Phi=90deg Freq=5170MHz]
  C2R4_B_V: dB(RealizedGainTotal), dB(GainTotal), dB(DirTotal), re(rETheta), im(rETheta), re(rEPhi), im(rEPhi) vs Theta on Centro : LastAdaptive, HV [Phi=0deg Freq=5170MHz]
