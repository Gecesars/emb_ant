# Ansys Electronics Desktop project, version 2024.2
materials:
  vacuum: permittivity=1
  POM_nom: permittivity=3.4 dielectric_loss_tangent=0.01
  PTFE_terminal: permittivity=2.0363635 dielectric_loss_tangent=0.00027683055
  ZYF300: permittivity=2.94 dielectric_loss_tangent=0.0016
  RO4350B_R01: permittivity=3.66 dielectric_loss_tangent=0.0037
  AL5052: conductivity=20000000
  SAC305: conductivity=7575758
  copper: permeability=0.999991 conductivity=58000000
  NiP_vol_nominal: permeability=1 conductivity=1500000
  Ouro_vol_nominal: permeability=1 conductivity=41000000
  Cobre_vol_Groiss: permeability=1 conductivity=28688604

design PCB_separada (HFSS, HFSS Hybrid Modal Network, model units mm)
geometry:
  Refletor_dobrado [AL5052] = imported_body(D:/dev/EMBRAER/P2M21/R00_Concepcao\antena\cad\AL5052.step)
  Berco_4_P, Berco_4_M, Berco_3_P, Berco_3_M, Berco_2_P, Berco_2_M, Berco_1_P, Berco_1_M [POM_nom] = imported_body(D:/dev/EMBRAER/P2M21/R00_Concepcao\antena\cad\POM_nom.step)
  PCB_Modulo_4, PCB_Modulo_3, PCB_Modulo_2, PCB_Modulo_1 [RO4350B_R01] = imported_body(D:/dev/EMBRAER/P2M21/R00_Concepcao\antena\cad\RO4350B_R01.step)
  E32_Solda_terminal_03, E32_Solda_terminal_02, E32_Solda_terminal_01, E32_Solda_terminal_00, E31_Solda_terminal_03, E31_Solda_terminal_02, E31_Solda_terminal_01, E31_Solda_terminal_00, E30_Solda_terminal_03, E30_Solda_terminal_02, E30_Solda_terminal_01, E30_Solda_terminal_00, E29_Solda_terminal_03, E29_Solda_terminal_02, E29_Solda_terminal_01, E29_Solda_terminal_00, E28_Solda_terminal_03, E28_Solda_terminal_02, E28_Solda_terminal_01, E28_Solda_terminal_00, E27_Solda_terminal_03, E27_Solda_terminal_02, E27_Solda_terminal_01, E27_Solda_terminal_00, E26_Solda_terminal_03, E26_Solda_terminal_02, E26_Solda_terminal_01, E26_Solda_terminal_00, E25_Solda_terminal_03, E25_Solda_terminal_02, E25_Solda_terminal_01, E25_Solda_terminal_00, E24_Solda_terminal_03, E24_Solda_terminal_02, E24_Solda_terminal_01, E24_Solda_terminal_00, E23_Solda_terminal_03, E23_Solda_terminal_02, E23_Solda_terminal_01, E23_Solda_terminal_00, E22_Solda_terminal_03, E22_Solda_terminal_02, E22_Solda_terminal_01, E22_Solda_terminal_00, E21_Solda_terminal_03, E21_Solda_terminal_02, E21_Solda_terminal_01, E21_Solda_terminal_00, E20_Solda_terminal_03, E20_Solda_terminal_02, E20_Solda_terminal_01, E20_Solda_terminal_00, E19_Solda_terminal_03, E19_Solda_terminal_02, E19_Solda_terminal_01, E19_Solda_terminal_00, E18_Solda_terminal_03, E18_Solda_terminal_02, E18_Solda_terminal_01, E18_Solda_terminal_00, E17_Solda_terminal_03, E17_Solda_terminal_02, E17_Solda_terminal_01, E17_Solda_terminal_00, E16_Solda_terminal_03, E16_Solda_terminal_02, E16_Solda_terminal_01, E16_Solda_terminal_00, E15_Solda_terminal_03, E15_Solda_terminal_02, E15_Solda_terminal_01, E15_Solda_terminal_00, E14_Solda_terminal_03, E14_Solda_terminal_02, E14_Solda_terminal_01, E14_Solda_terminal_00, E13_Solda_terminal_03, E13_Solda_terminal_02, E13_Solda_terminal_01, E13_Solda_terminal_00, E12_Solda_terminal_03, E12_Solda_terminal_02, E12_Solda_terminal_01, E12_Solda_terminal_00, E11_Solda_terminal_03, E11_Solda_terminal_02, E11_Solda_terminal_01, E11_Solda_terminal_00, E10_Solda_terminal_03, E10_Solda_terminal_02, E10_Solda_terminal_01, E10_Solda_terminal_00, E09_Solda_terminal_03, E09_Solda_terminal_02, E09_Solda_terminal_01, E09_Solda_terminal_00, E08_Solda_terminal_03, E08_Solda_terminal_02, E08_Solda_terminal_01, E08_Solda_terminal_00, E07_Solda_terminal_03, E07_Solda_terminal_02, E07_Solda_terminal_01, E07_Solda_terminal_00, E06_Solda_terminal_03, E06_Solda_terminal_02, E06_Solda_terminal_01, E06_Solda_terminal_00, E05_Solda_terminal_03, E05_Solda_terminal_02, E05_Solda_terminal_01, E05_Solda_terminal_00, E04_Solda_terminal_03, E04_Solda_terminal_02, E04_Solda_terminal_01, E04_Solda_terminal_00, E03_Solda_terminal_03, E03_Solda_terminal_02, E03_Solda_terminal_01, E03_Solda_terminal_00, E02_Solda_terminal_03, E02_Solda_terminal_02, E02_Solda_terminal_01, E02_Solda_terminal_00, E01_Solda_terminal_03, E01_Solda_terminal_02, E01_Solda_terminal_01, E01_Solda_terminal_00 [SAC305] = imported_body(D:/dev/EMBRAER/P2M21/R00_Concepcao\antena\cad\SAC305.step)
  E32_Capa_INF_B1, E32_Sinal_INF_B1, E32_Capa_INF_A1, E32_Sinal_INF_A1, E32_Via00_1, E32_Via00_0, E31_Capa_INF_B1, E31_Sinal_INF_B1, E31_Capa_INF_A1, E31_Sinal_INF_A1, E31_Via00_1, E31_Via00_0, E30_Capa_INF_B1, E30_Sinal_INF_B1, E30_Capa_INF_A1, E30_Sinal_INF_A1, E30_Via00_1, E30_Via00_0, E29_Capa_INF_B1, E29_Sinal_INF_B1, E29_Capa_INF_A1, E29_Sinal_INF_A1, E29_Via00_1, E29_Via00_0, E28_Capa_INF_B1, E28_Sinal_INF_B1, E28_Capa_INF_A1, E28_Sinal_INF_A1, E28_Via00_1, E28_Via00_0, E27_Capa_INF_B1, E27_Sinal_INF_B1, E27_Capa_INF_A1, E27_Sinal_INF_A1, E27_Via00_1, E27_Via00_0, E26_Capa_INF_B1, E26_Sinal_INF_B1, E26_Capa_INF_A1, E26_Sinal_INF_A1, E26_Via00_1, E26_Via00_0, E25_Capa_INF_B1, E25_Sinal_INF_B1, E25_Capa_INF_A1, E25_Sinal_INF_A1, E25_Via00_1, E25_Via00_0, E24_Capa_INF_B1, E24_Sinal_INF_B1, E24_Capa_INF_A1, E24_Sinal_INF_A1, E24_Via00_1, E24_Via00_0, E23_Capa_INF_B1, E23_Sinal_INF_B1, E23_Capa_INF_A1, E23_Sinal_INF_A1, E23_Via00_1, E23_Via00_0, E22_Capa_INF_B1, E22_Sinal_INF_B1, E22_Capa_INF_A1, E22_Sinal_INF_A1, E22_Via00_1, E22_Via00_0, E21_Capa_INF_B1, E21_Sinal_INF_B1, E21_Capa_INF_A1, E21_Sinal_INF_A1, E21_Via00_1, E21_Via00_0, E20_Capa_INF_B1, E20_Sinal_INF_B1, E20_Capa_INF_A1, E20_Sinal_INF_A1, E20_Via00_1, E20_Via00_0, E19_Capa_INF_B1, E19_Sinal_INF_B1, E19_Capa_INF_A1, E19_Sinal_INF_A1, E19_Via00_1, E19_Via00_0, E18_Capa_INF_B1, E18_Sinal_INF_B1, E18_Capa_INF_A1, E18_Sinal_INF_A1, E18_Via00_1, E18_Via00_0, E17_Capa_INF_B1, E17_Sinal_INF_B1, E17_Capa_INF_A1, E17_Sinal_INF_A1, E17_Via00_1, E17_Via00_0, E16_Capa_INF_B1, E16_Sinal_INF_B1, E16_Capa_INF_A1, E16_Sinal_INF_A1, E16_Via00_1, E16_Via00_0, E15_Capa_INF_B1, E15_Sinal_INF_B1, E15_Capa_INF_A1, E15_Sinal_INF_A1, E15_Via00_1, E15_Via00_0, E14_Capa_INF_B1, E14_Sinal_INF_B1, E14_Capa_INF_A1, E14_Sinal_INF_A1, E14_Via00_1, E14_Via00_0, E13_Capa_INF_B1, E13_Sinal_INF_B1, E13_Capa_INF_A1, E13_Sinal_INF_A1, E13_Via00_1, E13_Via00_0, E12_Capa_INF_B1, E12_Sinal_INF_B1, E12_Capa_INF_A1, E12_Sinal_INF_A1, E12_Via00_1, E12_Via00_0, E11_Capa_INF_B1, E11_Sinal_INF_B1, E11_Capa_INF_A1, E11_Sinal_INF_A1, E11_Via00_1, E11_Via00_0, E10_Capa_INF_B1, E10_Sinal_INF_B1, E10_Capa_INF_A1, E10_Sinal_INF_A1, E10_Via00_1, E10_Via00_0, E09_Capa_INF_B1, E09_Sinal_INF_B1, E09_Capa_INF_A1, E09_Sinal_INF_A1, E09_Via00_1, E09_Via00_0, E08_Capa_INF_B1, E08_Sinal_INF_B1, E08_Capa_INF_A1, E08_Sinal_INF_A1, E08_Via00_1, E08_Via00_0, E07_Capa_INF_B1, E07_Sinal_INF_B1, E07_Capa_INF_A1, E07_Sinal_INF_A1, E07_Via00_1, E07_Via00_0, E06_Capa_INF_B1, E06_Sinal_INF_B1, E06_Capa_INF_A1, E06_Sinal_INF_A1, E06_Via00_1, E06_Via00_0, E05_Capa_INF_B1, E05_Sinal_INF_B1, E05_Capa_INF_A1, E05_Sinal_INF_A1, E05_Via00_1, E05_Via00_0, E04_Capa_INF_B1, E04_Sinal_INF_B1, E04_Capa_INF_A1, E04_Sinal_INF_A1, E04_Via00_1, E04_Via00_0, E03_Capa_INF_B1, E03_Sinal_INF_B1, E03_Capa_INF_A1, E03_Sinal_INF_A1, E03_Via00_1, E03_Via00_0, E02_Capa_INF_B1, E02_Sinal_INF_B1, E02_Capa_INF_A1, E02_Sinal_INF_A1, E02_Via00_1, E02_Via00_0, E01_Capa_INF_B1, E01_Sinal_INF_B1, E01_Capa_INF_A1, E01_Sinal_INF_A1, E01_Via00_1, E01_Via00_0 [copper] = imported_body(D:/dev/EMBRAER/P2M21/R00_Concepcao\antena\cad\copper.step)
  E32_Ant01_Feed_B_Inner_Cu1, E32_Ant01_Feed_B_Inner_Cu0, E32_Ant01_Feed_B_Outer, E32_Ant01_Feed_A_Cu1, E32_Ant01_Feed_A_Cu0, E32_Ant01_Crossover_Bridge, E32_Ant01_Ring_Q4, E32_Ant01_Ring_Q3, E32_Ant01_Ring_Q2, E32_Ant01_Ring_Q1, E31_Ant01_Feed_B_Inner_Cu1, E31_Ant01_Feed_B_Inner_Cu0, E31_Ant01_Feed_B_Outer, E31_Ant01_Feed_A_Cu1, E31_Ant01_Feed_A_Cu0, E31_Ant01_Crossover_Bridge, E31_Ant01_Ring_Q4, E31_Ant01_Ring_Q3, E31_Ant01_Ring_Q2, E31_Ant01_Ring_Q1, E30_Ant01_Feed_B_Inner_Cu1, E30_Ant01_Feed_B_Inner_Cu0, E30_Ant01_Feed_B_Outer, E30_Ant01_Feed_A_Cu1, E30_Ant01_Feed_A_Cu0, E30_Ant01_Crossover_Bridge, E30_Ant01_Ring_Q4, E30_Ant01_Ring_Q3, E30_Ant01_Ring_Q2, E30_Ant01_Ring_Q1, E29_Ant01_Feed_B_Inner_Cu1, E29_Ant01_Feed_B_Inner_Cu0, E29_Ant01_Feed_B_Outer, E29_Ant01_Feed_A_Cu1, E29_Ant01_Feed_A_Cu0, E29_Ant01_Crossover_Bridge, E29_Ant01_Ring_Q4, E29_Ant01_Ring_Q3, E29_Ant01_Ring_Q2, E29_Ant01_Ring_Q1, E28_Ant01_Feed_B_Inner_Cu1, E28_Ant01_Feed_B_Inner_Cu0, E28_Ant01_Feed_B_Outer, E28_Ant01_Feed_A_Cu1, E28_Ant01_Feed_A_Cu0, E28_Ant01_Crossover_Bridge, E28_Ant01_Ring_Q4, E28_Ant01_Ring_Q3, E28_Ant01_Ring_Q2, E28_Ant01_Ring_Q1, E27_Ant01_Feed_B_Inner_Cu1, E27_Ant01_Feed_B_Inner_Cu0, E27_Ant01_Feed_B_Outer, E27_Ant01_Feed_A_Cu1, E27_Ant01_Feed_A_Cu0, E27_Ant01_Crossover_Bridge, E27_Ant01_Ring_Q4, E27_Ant01_Ring_Q3, E27_Ant01_Ring_Q2, E27_Ant01_Ring_Q1, E26_Ant01_Feed_B_Inner_Cu1, E26_Ant01_Feed_B_Inner_Cu0, E26_Ant01_Feed_B_Outer, E26_Ant01_Feed_A_Cu1, E26_Ant01_Feed_A_Cu0, E26_Ant01_Crossover_Bridge, E26_Ant01_Ring_Q4, E26_Ant01_Ring_Q3, E26_Ant01_Ring_Q2, E26_Ant01_Ring_Q1, E25_Ant01_Feed_B_Inner_Cu1, E25_Ant01_Feed_B_Inner_Cu0, E25_Ant01_Feed_B_Outer, E25_Ant01_Feed_A_Cu1, E25_Ant01_Feed_A_Cu0, E25_Ant01_Crossover_Bridge, E25_Ant01_Ring_Q4, E25_Ant01_Ring_Q3, E25_Ant01_Ring_Q2, E25_Ant01_Ring_Q1, E24_Ant01_Feed_B_Inner_Cu1, E24_Ant01_Feed_B_Inner_Cu0, E24_Ant01_Feed_B_Outer, E24_Ant01_Feed_A_Cu1, E24_Ant01_Feed_A_Cu0, E24_Ant01_Crossover_Bridge, E24_Ant01_Ring_Q4, E24_Ant01_Ring_Q3, E24_Ant01_Ring_Q2, E24_Ant01_Ring_Q1, E23_Ant01_Feed_B_Inner_Cu1, E23_Ant01_Feed_B_Inner_Cu0, E23_Ant01_Feed_B_Outer, E23_Ant01_Feed_A_Cu1, E23_Ant01_Feed_A_Cu0, E23_Ant01_Crossover_Bridge, E23_Ant01_Ring_Q4, E23_Ant01_Ring_Q3, E23_Ant01_Ring_Q2, E23_Ant01_Ring_Q1, E22_Ant01_Feed_B_Inner_Cu1, E22_Ant01_Feed_B_Inner_Cu0, E22_Ant01_Feed_B_Outer, E22_Ant01_Feed_A_Cu1, E22_Ant01_Feed_A_Cu0, E22_Ant01_Crossover_Bridge, E22_Ant01_Ring_Q4, E22_Ant01_Ring_Q3, E22_Ant01_Ring_Q2, E22_Ant01_Ring_Q1, E21_Ant01_Feed_B_Inner_Cu1, E21_Ant01_Feed_B_Inner_Cu0, E21_Ant01_Feed_B_Outer, E21_Ant01_Feed_A_Cu1, E21_Ant01_Feed_A_Cu0, E21_Ant01_Crossover_Bridge, E21_Ant01_Ring_Q4, E21_Ant01_Ring_Q3, E21_Ant01_Ring_Q2, E21_Ant01_Ring_Q1, E20_Ant01_Feed_B_Inner_Cu1, E20_Ant01_Feed_B_Inner_Cu0, E20_Ant01_Feed_B_Outer, E20_Ant01_Feed_A_Cu1, E20_Ant01_Feed_A_Cu0, E20_Ant01_Crossover_Bridge, E20_Ant01_Ring_Q4, E20_Ant01_Ring_Q3, E20_Ant01_Ring_Q2, E20_Ant01_Ring_Q1, E19_Ant01_Feed_B_Inner_Cu1, E19_Ant01_Feed_B_Inner_Cu0, E19_Ant01_Feed_B_Outer, E19_Ant01_Feed_A_Cu1, E19_Ant01_Feed_A_Cu0, E19_Ant01_Crossover_Bridge, E19_Ant01_Ring_Q4, E19_Ant01_Ring_Q3, E19_Ant01_Ring_Q2, E19_Ant01_Ring_Q1, E18_Ant01_Feed_B_Inner_Cu1, E18_Ant01_Feed_B_Inner_Cu0, E18_Ant01_Feed_B_Outer, E18_Ant01_Feed_A_Cu1, E18_Ant01_Feed_A_Cu0, E18_Ant01_Crossover_Bridge, E18_Ant01_Ring_Q4, E18_Ant01_Ring_Q3, E18_Ant01_Ring_Q2, E18_Ant01_Ring_Q1, E17_Ant01_Feed_B_Inner_Cu1, E17_Ant01_Feed_B_Inner_Cu0, E17_Ant01_Feed_B_Outer, E17_Ant01_Feed_A_Cu1, E17_Ant01_Feed_A_Cu0, E17_Ant01_Crossover_Bridge, E17_Ant01_Ring_Q4, E17_Ant01_Ring_Q3, E17_Ant01_Ring_Q2, E17_Ant01_Ring_Q1, E16_Ant01_Feed_B_Inner_Cu1, E16_Ant01_Feed_B_Inner_Cu0, E16_Ant01_Feed_B_Outer, E16_Ant01_Feed_A_Cu1, E16_Ant01_Feed_A_Cu0, E16_Ant01_Crossover_Bridge, E16_Ant01_Ring_Q4, E16_Ant01_Ring_Q3, E16_Ant01_Ring_Q2, E16_Ant01_Ring_Q1, E15_Ant01_Feed_B_Inner_Cu1, E15_Ant01_Feed_B_Inner_Cu0, E15_Ant01_Feed_B_Outer, E15_Ant01_Feed_A_Cu1, E15_Ant01_Feed_A_Cu0, E15_Ant01_Crossover_Bridge, E15_Ant01_Ring_Q4, E15_Ant01_Ring_Q3, E15_Ant01_Ring_Q2, E15_Ant01_Ring_Q1, E14_Ant01_Feed_B_Inner_Cu1, E14_Ant01_Feed_B_Inner_Cu0, E14_Ant01_Feed_B_Outer, E14_Ant01_Feed_A_Cu1, E14_Ant01_Feed_A_Cu0, E14_Ant01_Crossover_Bridge, E14_Ant01_Ring_Q4, E14_Ant01_Ring_Q3, E14_Ant01_Ring_Q2, E14_Ant01_Ring_Q1, E13_Ant01_Feed_B_Inner_Cu1, E13_Ant01_Feed_B_Inner_Cu0, E13_Ant01_Feed_B_Outer, E13_Ant01_Feed_A_Cu1, E13_Ant01_Feed_A_Cu0, E13_Ant01_Crossover_Bridge, E13_Ant01_Ring_Q4, E13_Ant01_Ring_Q3, E13_Ant01_Ring_Q2, E13_Ant01_Ring_Q1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 [Cobre_vol_Groiss] = imported_body(D:/dev/EMBRAER/P2M21/R00_Concepcao\antena\cad\folha_cu.step)
  E01_A_ext = circle(normal=Z, centre=(-391.99083mm, -22.509168mm, 16.575mm), radius=0.834856mm)
  E01_A_int = circle(normal=Z, centre=(-391.99083mm, -22.509168mm, 16.575mm), radius=0.6mm)
  E01_A_ext.subtract(E01_A_int)
  E01_B_ext = circle(normal=Z, centre=(-391.99083mm, -17.490832mm, 16.575mm), radius=0.834856mm)
  E01_B_int = circle(normal=Z, centre=(-391.99083mm, -17.490832mm, 16.575mm), radius=0.6mm)
  E01_B_ext.subtract(E01_B_int)
  E02_A_ext = circle(normal=Z, centre=(-391.99083mm, 17.490832mm, 16.575mm), radius=0.834856mm)
  E02_A_int = circle(normal=Z, centre=(-391.99083mm, 17.490832mm, 16.575mm), radius=0.6mm)
  E02_A_ext.subtract(E02_A_int)
  E02_B_ext = circle(normal=Z, centre=(-391.99083mm, 22.509168mm, 16.575mm), radius=0.834856mm)
  E02_B_int = circle(normal=Z, centre=(-391.99083mm, 22.509168mm, 16.575mm), radius=0.6mm)
  E02_B_ext.subtract(E02_B_int)
  E03_A_ext = circle(normal=Z, centre=(-339.39083mm, -22.509168mm, 16.575mm), radius=0.834856mm)
  E03_A_int = circle(normal=Z, centre=(-339.39083mm, -22.509168mm, 16.575mm), radius=0.6mm)
  E03_A_ext.subtract(E03_A_int)
  E03_B_ext = circle(normal=Z, centre=(-339.39083mm, -17.490832mm, 16.575mm), radius=0.834856mm)
  E03_B_int = circle(normal=Z, centre=(-339.39083mm, -17.490832mm, 16.575mm), radius=0.6mm)
  E03_B_ext.subtract(E03_B_int)
  E04_A_ext = circle(normal=Z, centre=(-339.39083mm, 17.490832mm, 16.575mm), radius=0.834856mm)
  E04_A_int = circle(normal=Z, centre=(-339.39083mm, 17.490832mm, 16.575mm), radius=0.6mm)
  E04_A_ext.subtract(E04_A_int)
  E04_B_ext = circle(normal=Z, centre=(-339.39083mm, 22.509168mm, 16.575mm), radius=0.834856mm)
  E04_B_int = circle(normal=Z, centre=(-339.39083mm, 22.509168mm, 16.575mm), radius=0.6mm)
  E04_B_ext.subtract(E04_B_int)
  E05_A_ext = circle(normal=Z, centre=(-286.79083mm, -22.509168mm, 16.575mm), radius=0.834856mm)
  E05_A_int = circle(normal=Z, centre=(-286.79083mm, -22.509168mm, 16.575mm), radius=0.6mm)
  E05_A_ext.subtract(E05_A_int)
  E05_B_ext = circle(normal=Z, centre=(-286.79083mm, -17.490832mm, 16.575mm), radius=0.834856mm)
  E05_B_int = circle(normal=Z, centre=(-286.79083mm, -17.490832mm, 16.575mm), radius=0.6mm)
  E05_B_ext.subtract(E05_B_int)
  E06_A_ext = circle(normal=Z, centre=(-286.79083mm, 17.490832mm, 16.575mm), radius=0.834856mm)
  E06_A_int = circle(normal=Z, centre=(-286.79083mm, 17.490832mm, 16.575mm), radius=0.6mm)
  E06_A_ext.subtract(E06_A_int)
  E06_B_ext = circle(normal=Z, centre=(-286.79083mm, 22.509168mm, 16.575mm), radius=0.834856mm)
  E06_B_int = circle(normal=Z, centre=(-286.79083mm, 22.509168mm, 16.575mm), radius=0.6mm)
  E06_B_ext.subtract(E06_B_int)
  E07_A_ext = circle(normal=Z, centre=(-234.19083mm, -22.509168mm, 16.575mm), radius=0.834856mm)
  E07_A_int = circle(normal=Z, centre=(-234.19083mm, -22.509168mm, 16.575mm), radius=0.6mm)
  E07_A_ext.subtract(E07_A_int)
  E07_B_ext = circle(normal=Z, centre=(-234.19083mm, -17.490832mm, 16.575mm), radius=0.834856mm)
  E07_B_int = circle(normal=Z, centre=(-234.19083mm, -17.490832mm, 16.575mm), radius=0.6mm)
  E07_B_ext.subtract(E07_B_int)
  E08_A_ext = circle(normal=Z, centre=(-234.19083mm, 17.490832mm, 16.575mm), radius=0.834856mm)
  E08_A_int = circle(normal=Z, centre=(-234.19083mm, 17.490832mm, 16.575mm), radius=0.6mm)
  E08_A_ext.subtract(E08_A_int)
  E08_B_ext = circle(normal=Z, centre=(-234.19083mm, 22.509168mm, 16.575mm), radius=0.834856mm)
  E08_B_int = circle(normal=Z, centre=(-234.19083mm, 22.509168mm, 16.575mm), radius=0.6mm)
  E08_B_ext.subtract(E08_B_int)
  E09_A_ext = circle(normal=Z, centre=(-181.59083mm, -22.509168mm, 16.575mm), radius=0.834856mm)
  E09_A_int = circle(normal=Z, centre=(-181.59083mm, -22.509168mm, 16.575mm), radius=0.6mm)
  E09_A_ext.subtract(E09_A_int)
  E09_B_ext = circle(normal=Z, centre=(-181.59083mm, -17.490832mm, 16.575mm), radius=0.834856mm)
  E09_B_int = circle(normal=Z, centre=(-181.59083mm, -17.490832mm, 16.575mm), radius=0.6mm)
  E09_B_ext.subtract(E09_B_int)
  E10_A_ext = circle(normal=Z, centre=(-181.59083mm, 17.490832mm, 16.575mm), radius=0.834856mm)
  E10_A_int = circle(normal=Z, centre=(-181.59083mm, 17.490832mm, 16.575mm), radius=0.6mm)
  E10_A_ext.subtract(E10_A_int)
  E10_B_ext = circle(normal=Z, centre=(-181.59083mm, 22.509168mm, 16.575mm), radius=0.834856mm)
  E10_B_int = circle(normal=Z, centre=(-181.59083mm, 22.509168mm, 16.575mm), radius=0.6mm)
  E10_B_ext.subtract(E10_B_int)
  E11_A_ext = circle(normal=Z, centre=(-128.99083mm, -22.509168mm, 16.575mm), radius=0.834856mm)
  E11_A_int = circle(normal=Z, centre=(-128.99083mm, -22.509168mm, 16.575mm), radius=0.6mm)
  E11_A_ext.subtract(E11_A_int)
  E11_B_ext = circle(normal=Z, centre=(-128.99083mm, -17.490832mm, 16.575mm), radius=0.834856mm)
  E11_B_int = circle(normal=Z, centre=(-128.99083mm, -17.490832mm, 16.575mm), radius=0.6mm)
  E11_B_ext.subtract(E11_B_int)
  E12_A_ext = circle(normal=Z, centre=(-128.99083mm, 17.490832mm, 16.575mm), radius=0.834856mm)
  E12_A_int = circle(normal=Z, centre=(-128.99083mm, 17.490832mm, 16.575mm), radius=0.6mm)
  E12_A_ext.subtract(E12_A_int)
  E12_B_ext = circle(normal=Z, centre=(-128.99083mm, 22.509168mm, 16.575mm), radius=0.834856mm)
  E12_B_int = circle(normal=Z, centre=(-128.99083mm, 22.509168mm, 16.575mm), radius=0.6mm)
  E12_B_ext.subtract(E12_B_int)
  E13_A_ext = circle(normal=Z, centre=(-76.390832mm, -22.509168mm, 16.575mm), radius=0.834856mm)
  E13_A_int = circle(normal=Z, centre=(-76.390832mm, -22.509168mm, 16.575mm), radius=0.6mm)
  E13_A_ext.subtract(E13_A_int)
  E13_B_ext = circle(normal=Z, centre=(-76.390832mm, -17.490832mm, 16.575mm), radius=0.834856mm)
  E13_B_int = circle(normal=Z, centre=(-76.390832mm, -17.490832mm, 16.575mm), radius=0.6mm)
  E13_B_ext.subtract(E13_B_int)
  E14_A_ext = circle(normal=Z, centre=(-76.390832mm, 17.490832mm, 16.575mm), radius=0.834856mm)
  E14_A_int = circle(normal=Z, centre=(-76.390832mm, 17.490832mm, 16.575mm), radius=0.6mm)
  E14_A_ext.subtract(E14_A_int)
  E14_B_ext = circle(normal=Z, centre=(-76.390832mm, 22.509168mm, 16.575mm), radius=0.834856mm)
  E14_B_int = circle(normal=Z, centre=(-76.390832mm, 22.509168mm, 16.575mm), radius=0.6mm)
  E14_B_ext.subtract(E14_B_int)
  E15_A_ext = circle(normal=Z, centre=(-23.790832mm, -22.509168mm, 16.575mm), radius=0.834856mm)
  E15_A_int = circle(normal=Z, centre=(-23.790832mm, -22.509168mm, 16.575mm), radius=0.6mm)
  E15_A_ext.subtract(E15_A_int)
  E15_B_ext = circle(normal=Z, centre=(-23.790832mm, -17.490832mm, 16.575mm), radius=0.834856mm)
  E15_B_int = circle(normal=Z, centre=(-23.790832mm, -17.490832mm, 16.575mm), radius=0.6mm)
  E15_B_ext.subtract(E15_B_int)
  E16_A_ext = circle(normal=Z, centre=(-23.790832mm, 17.490832mm, 16.575mm), radius=0.834856mm)
  E16_A_int = circle(normal=Z, centre=(-23.790832mm, 17.490832mm, 16.575mm), radius=0.6mm)
  E16_A_ext.subtract(E16_A_int)
  E16_B_ext = circle(normal=Z, centre=(-23.790832mm, 22.509168mm, 16.575mm), radius=0.834856mm)
  E16_B_int = circle(normal=Z, centre=(-23.790832mm, 22.509168mm, 16.575mm), radius=0.6mm)
  E16_B_ext.subtract(E16_B_int)
  E17_A_ext = circle(normal=Z, centre=(28.809168mm, -22.509168mm, 16.575mm), radius=0.834856mm)
  E17_A_int = circle(normal=Z, centre=(28.809168mm, -22.509168mm, 16.575mm), radius=0.6mm)
  E17_A_ext.subtract(E17_A_int)
  E17_B_ext = circle(normal=Z, centre=(28.809168mm, -17.490832mm, 16.575mm), radius=0.834856mm)
  E17_B_int = circle(normal=Z, centre=(28.809168mm, -17.490832mm, 16.575mm), radius=0.6mm)
  E17_B_ext.subtract(E17_B_int)
  E18_A_ext = circle(normal=Z, centre=(28.809168mm, 17.490832mm, 16.575mm), radius=0.834856mm)
  E18_A_int = circle(normal=Z, centre=(28.809168mm, 17.490832mm, 16.575mm), radius=0.6mm)
  E18_A_ext.subtract(E18_A_int)
  E18_B_ext = circle(normal=Z, centre=(28.809168mm, 22.509168mm, 16.575mm), radius=0.834856mm)
  E18_B_int = circle(normal=Z, centre=(28.809168mm, 22.509168mm, 16.575mm), radius=0.6mm)
  E18_B_ext.subtract(E18_B_int)
  E19_A_ext = circle(normal=Z, centre=(81.409168mm, -22.509168mm, 16.575mm), radius=0.834856mm)
  E19_A_int = circle(normal=Z, centre=(81.409168mm, -22.509168mm, 16.575mm), radius=0.6mm)
  E19_A_ext.subtract(E19_A_int)
  E19_B_ext = circle(normal=Z, centre=(81.409168mm, -17.490832mm, 16.575mm), radius=0.834856mm)
  E19_B_int = circle(normal=Z, centre=(81.409168mm, -17.490832mm, 16.575mm), radius=0.6mm)
  E19_B_ext.subtract(E19_B_int)
  E20_A_ext = circle(normal=Z, centre=(81.409168mm, 17.490832mm, 16.575mm), radius=0.834856mm)
  E20_A_int = circle(normal=Z, centre=(81.409168mm, 17.490832mm, 16.575mm), radius=0.6mm)
  E20_A_ext.subtract(E20_A_int)
  E20_B_ext = circle(normal=Z, centre=(81.409168mm, 22.509168mm, 16.575mm), radius=0.834856mm)
  E20_B_int = circle(normal=Z, centre=(81.409168mm, 22.509168mm, 16.575mm), radius=0.6mm)
  E20_B_ext.subtract(E20_B_int)
  E21_A_ext = circle(normal=Z, centre=(134.00917mm, -22.509168mm, 16.575mm), radius=0.834856mm)
  E21_A_int = circle(normal=Z, centre=(134.00917mm, -22.509168mm, 16.575mm), radius=0.6mm)
  E21_A_ext.subtract(E21_A_int)
  E21_B_ext = circle(normal=Z, centre=(134.00917mm, -17.490832mm, 16.575mm), radius=0.834856mm)
  E21_B_int = circle(normal=Z, centre=(134.00917mm, -17.490832mm, 16.575mm), radius=0.6mm)
  E21_B_ext.subtract(E21_B_int)
  E22_A_ext = circle(normal=Z, centre=(134.00917mm, 17.490832mm, 16.575mm), radius=0.834856mm)
  E22_A_int = circle(normal=Z, centre=(134.00917mm, 17.490832mm, 16.575mm), radius=0.6mm)
  E22_A_ext.subtract(E22_A_int)
  E22_B_ext = circle(normal=Z, centre=(134.00917mm, 22.509168mm, 16.575mm), radius=0.834856mm)
  E22_B_int = circle(normal=Z, centre=(134.00917mm, 22.509168mm, 16.575mm), radius=0.6mm)
  E22_B_ext.subtract(E22_B_int)
  E23_A_ext = circle(normal=Z, centre=(186.60917mm, -22.509168mm, 16.575mm), radius=0.834856mm)
  E23_A_int = circle(normal=Z, centre=(186.60917mm, -22.509168mm, 16.575mm), radius=0.6mm)
  E23_A_ext.subtract(E23_A_int)
  E23_B_ext = circle(normal=Z, centre=(186.60917mm, -17.490832mm, 16.575mm), radius=0.834856mm)
  E23_B_int = circle(normal=Z, centre=(186.60917mm, -17.490832mm, 16.575mm), radius=0.6mm)
  E23_B_ext.subtract(E23_B_int)
  E24_A_ext = circle(normal=Z, centre=(186.60917mm, 17.490832mm, 16.575mm), radius=0.834856mm)
  E24_A_int = circle(normal=Z, centre=(186.60917mm, 17.490832mm, 16.575mm), radius=0.6mm)
  E24_A_ext.subtract(E24_A_int)
  E24_B_ext = circle(normal=Z, centre=(186.60917mm, 22.509168mm, 16.575mm), radius=0.834856mm)
  E24_B_int = circle(normal=Z, centre=(186.60917mm, 22.509168mm, 16.575mm), radius=0.6mm)
  E24_B_ext.subtract(E24_B_int)
  E25_A_ext = circle(normal=Z, centre=(239.20917mm, -22.509168mm, 16.575mm), radius=0.834856mm)
  E25_A_int = circle(normal=Z, centre=(239.20917mm, -22.509168mm, 16.575mm), radius=0.6mm)
  E25_A_ext.subtract(E25_A_int)
  E25_B_ext = circle(normal=Z, centre=(239.20917mm, -17.490832mm, 16.575mm), radius=0.834856mm)
  E25_B_int = circle(normal=Z, centre=(239.20917mm, -17.490832mm, 16.575mm), radius=0.6mm)
  E25_B_ext.subtract(E25_B_int)
  E26_A_ext = circle(normal=Z, centre=(239.20917mm, 17.490832mm, 16.575mm), radius=0.834856mm)
  E26_A_int = circle(normal=Z, centre=(239.20917mm, 17.490832mm, 16.575mm), radius=0.6mm)
  E26_A_ext.subtract(E26_A_int)
  E26_B_ext = circle(normal=Z, centre=(239.20917mm, 22.509168mm, 16.575mm), radius=0.834856mm)
  E26_B_int = circle(normal=Z, centre=(239.20917mm, 22.509168mm, 16.575mm), radius=0.6mm)
  E26_B_ext.subtract(E26_B_int)
  E27_A_ext = circle(normal=Z, centre=(291.80917mm, -22.509168mm, 16.575mm), radius=0.834856mm)
  E27_A_int = circle(normal=Z, centre=(291.80917mm, -22.509168mm, 16.575mm), radius=0.6mm)
  E27_A_ext.subtract(E27_A_int)
  E27_B_ext = circle(normal=Z, centre=(291.80917mm, -17.490832mm, 16.575mm), radius=0.834856mm)
  E27_B_int = circle(normal=Z, centre=(291.80917mm, -17.490832mm, 16.575mm), radius=0.6mm)
  E27_B_ext.subtract(E27_B_int)
  E28_A_ext = circle(normal=Z, centre=(291.80917mm, 17.490832mm, 16.575mm), radius=0.834856mm)
  E28_A_int = circle(normal=Z, centre=(291.80917mm, 17.490832mm, 16.575mm), radius=0.6mm)
  E28_A_ext.subtract(E28_A_int)
  E28_B_ext = circle(normal=Z, centre=(291.80917mm, 22.509168mm, 16.575mm), radius=0.834856mm)
  E28_B_int = circle(normal=Z, centre=(291.80917mm, 22.509168mm, 16.575mm), radius=0.6mm)
  E28_B_ext.subtract(E28_B_int)
  E29_A_ext = circle(normal=Z, centre=(344.40917mm, -22.509168mm, 16.575mm), radius=0.834856mm)
  E29_A_int = circle(normal=Z, centre=(344.40917mm, -22.509168mm, 16.575mm), radius=0.6mm)
  E29_A_ext.subtract(E29_A_int)
  E29_B_ext = circle(normal=Z, centre=(344.40917mm, -17.490832mm, 16.575mm), radius=0.834856mm)
  E29_B_int = circle(normal=Z, centre=(344.40917mm, -17.490832mm, 16.575mm), radius=0.6mm)
  E29_B_ext.subtract(E29_B_int)
  E30_A_ext = circle(normal=Z, centre=(344.40917mm, 17.490832mm, 16.575mm), radius=0.834856mm)
  E30_A_int = circle(normal=Z, centre=(344.40917mm, 17.490832mm, 16.575mm), radius=0.6mm)
  E30_A_ext.subtract(E30_A_int)
  E30_B_ext = circle(normal=Z, centre=(344.40917mm, 22.509168mm, 16.575mm), radius=0.834856mm)
  E30_B_int = circle(normal=Z, centre=(344.40917mm, 22.509168mm, 16.575mm), radius=0.6mm)
  E30_B_ext.subtract(E30_B_int)
  E31_A_ext = circle(normal=Z, centre=(397.00917mm, -22.509168mm, 16.575mm), radius=0.834856mm)
  E31_A_int = circle(normal=Z, centre=(397.00917mm, -22.509168mm, 16.575mm), radius=0.6mm)
  E31_A_ext.subtract(E31_A_int)
  E31_B_ext = circle(normal=Z, centre=(397.00917mm, -17.490832mm, 16.575mm), radius=0.834856mm)
  E31_B_int = circle(normal=Z, centre=(397.00917mm, -17.490832mm, 16.575mm), radius=0.6mm)
  E31_B_ext.subtract(E31_B_int)
  E32_A_ext = circle(normal=Z, centre=(397.00917mm, 17.490832mm, 16.575mm), radius=0.834856mm)
  E32_A_int = circle(normal=Z, centre=(397.00917mm, 17.490832mm, 16.575mm), radius=0.6mm)
  E32_A_ext.subtract(E32_A_int)
  E32_B_ext = circle(normal=Z, centre=(397.00917mm, 22.509168mm, 16.575mm), radius=0.834856mm)
  E32_B_int = circle(normal=Z, centre=(397.00917mm, 22.509168mm, 16.575mm), radius=0.6mm)
  E32_B_ext.subtract(E32_B_int)
  RadiatingSurface [vacuum] = region(absolute_offset=19.646365mm on all sides)
boundaries and excitations:
  ENIG_faces_expostas: Layered Impedance Faces=E01_Ant01_Crossover_Bridge.face(at (-394.847, -19.653, 16.5925), at (-393.486, -18.9857, 16.5925), at (-394.153, -20.347, 16.5925), at (-395.514, -21.0143, 16.5925), at (-395.472, -20.7474, 16.5925), at (-393.978, -19.2526, 16.5925), at (-394.5, -20, 16.575)) E01_Ant01_Feed_A_Cu0.face(at (-401.669, -18.4682, 17.3875), at (-399.796, -17.9775, 17.3875), at (-396.749, -17.751, 17.405), at (-399.593, -18.959, 17.3875), at (-397.223, -17.2773, 17.3875), at (-396.523, -14.7041, 17.3875), at (-396.032, -12.8312, 17.3875), at (-395.541, -14.9074, 17.3875), at (-395.861, -17.304, 17.3875), at (-394.035, -19.7712, 17.3875), at (-392.415, -22.0849, 17.3875), at (-394.729, -20.4652, 17.3875)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) E01_Ant01_Feed_A_Cu1.face(at (-391.602, -22.8981, 17.405), at (-391.255, -22.5511, 17.3875), at (-391.457, -23.043, 17.3875), at (-391.949, -23.2452, 17.3875), at (-391.567, -22.9334, 17.3875)) E01_Ant01_Feed_B_Inner_Cu0.face(at (-393.474, -18.2802, 17.3875), at (-392.415, -17.9151, 17.3875), at (-393.127, -18.6272, 17.405), at (-394.02, -19.5195, 17.3875), at (-392.78, -18.9742, 17.3875), at (-393.978, -19.2526, 17.3875)) E01_Ant01_Feed_B_Inner_Cu1.face(at (-391.949, -16.7548, 17.3875), at (-391.457, -16.957, 17.3875), at (-391.602, -17.1019, 17.405), at (-391.255, -17.4489, 17.3875), at (-391.567, -17.0666, 17.3875)) E01_Ant01_Feed_B_Outer.face(at (-401.669, -21.5318, 17.3875), at (-399.593, -21.041, 17.3875), at (-397.196, -21.3614, 17.3875), at (-396.102, -20.9076, 17.3875), at (-394.98, -20.4805, 17.3875), at (-395.408, -21.6016, 17.3875), at (-395.861, -22.696, 17.3875), at (-395.541, -25.0926, 17.3875), at (-396.032, -27.1688, 17.3875), at (-396.523, -25.2959, 17.3875), at (-397.223, -22.7227, 17.3875), at (-399.796, -22.0225, 17.3875)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) E01_Ant01_Ring_Q1.face(at (-383.682, -9.18165, 16.5925), at (-381.251, -13.3754, 16.5925), at (-383.549, -17.437, 16.5925), at (-388.971, -19.7356, 16.5925), at (-393.164, -18.6644, 16.5925), at (-394.236, -14.4706, 16.5925), at (-391.937, -9.04944, 16.5925), at (-387.875, -6.75086, 16.5925), at (-393.261, -17.4908, 16.5925), at (-383.962, -16.1401, 16.5925), at (-382.533, -13.3754, 16.5925), at (-384.536, -10.0364, 16.5925)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) E01_Ant01_Ring_Q2.face(at (-400.094, -19.7325, 16.5925), at (-405.579, -17.407, 16.5925), at (-407.904, -13.298, 16.5925), at (-405.445, -9.05517, 16.5925), at (-401.202, -6.59596, 16.5925), at (-397.093, -8.9214, 16.5925), at (-394.768, -14.406, 16.5925), at (-395.851, -18.6488, 16.5925), at (-396.959, -12.8386, 16.5925), at (-398.405, -9.33892, 16.5925), at (-401.202, -7.89312, 16.5925), at (-404.58, -9.91994, 16.5925)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) E01_Ant01_Ring_Q3.face(at (-397.063, -30.9506, 16.5925), at (-401.125, -33.2491, 16.5925), at (-405.318, -30.8183, 16.5925), at (-407.749, -26.6246, 16.5925), at (-405.451, -22.563, 16.5925), at (-400.029, -20.2644, 16.5925), at (-395.836, -21.3356, 16.5925), at (-394.764, -25.5294, 16.5925), at (-398.24, -23.7397, 16.5925), at (-401.579, -22.4308, 16.5925), at (-405.038, -23.8599, 16.5925), at (-406.467, -26.6246, 16.5925)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) E01_Ant01_Ring_Q4.face(at (-381.096, -26.702, 16.5925), at (-383.555, -30.9448, 16.5925), at (-387.798, -33.404, 16.5925), at (-391.907, -31.0786, 16.5925), at (-394.232, -25.594, 16.5925), at (-393.149, -21.3512, 16.5925), at (-388.906, -20.2675, 16.5925), at (-383.421, -22.593, 16.5925), at (-387.798, -32.1069, 16.5925), at (-384.42, -30.0801, 16.5925), at (-382.393, -26.702, 16.5925), at (-383.839, -23.905, 16.5925)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) E02_Ant01_Crossover_Bridge.face(at (-394.847, 20.347, 16.5925), at (-393.486, 21.0143, 16.5925), at (-394.153, 19.653, 16.5925), at (-395.514, 18.9857, 16.5925), at (-395.472, 19.2526, 16.5925), at (-393.978, 20.7474, 16.5925), at (-394.5, 20, 16.575)) E02_Ant01_Feed_A_Cu0.face(at (-401.669, 21.5318, 17.3875), at (-399.796, 22.0225, 17.3875), at (-396.749, 22.249, 17.405), at (-399.593, 21.041, 17.3875), at (-397.223, 22.7227, 17.3875), at (-396.523, 25.2959, 17.3875), at (-396.032, 27.1688, 17.3875), at (-395.541, 25.0926, 17.3875), at (-395.861, 22.696, 17.3875), at (-394.035, 20.2288, 17.3875), at (-392.415, 17.9151, 17.3875), at (-394.729, 19.5348, 17.3875)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) E02_Ant01_Feed_A_Cu1.face(at (-391.602, 17.1019, 17.405), at (-391.255, 17.4489, 17.3875), at (-391.457, 16.957, 17.3875), at (-391.949, 16.7548, 17.3875), at (-391.567, 17.0666, 17.3875)) E02_Ant01_Feed_B_Inner_Cu0.face(at (-393.474, 21.7198, 17.3875), at (-392.415, 22.0849, 17.3875), at (-393.127, 21.3728, 17.405), at (-394.02, 20.4805, 17.3875), at (-392.78, 21.0258, 17.3875), at (-393.978, 20.7474, 17.3875)) E02_Ant01_Feed_B_Inner_Cu1.face(at (-391.949, 23.2452, 17.3875), at (-391.457, 23.043, 17.3875), at (-391.602, 22.8981, 17.405), at (-391.255, 22.5511, 17.3875), at (-391.567, 22.9334, 17.3875)) E02_Ant01_Feed_B_Outer.face(at (-401.669, 18.4682, 17.3875), at (-399.593, 18.959, 17.3875), at (-397.196, 18.6386, 17.3875), at (-396.102, 19.0924, 17.3875), at (-394.98, 19.5195, 17.3875), at (-395.408, 18.3984, 17.3875), at (-395.861, 17.304, 17.3875), at (-395.541, 14.9074, 17.3875), at (-396.032, 12.8312, 17.3875), at (-396.523, 14.7041, 17.3875), at (-397.223, 17.2773, 17.3875), at (-399.796, 17.9775, 17.3875)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) E02_Ant01_Ring_Q1.face(at (-383.682, 30.8183, 16.5925), at (-381.251, 26.6246, 16.5925), at (-383.549, 22.563, 16.5925), at (-388.971, 20.2644, 16.5925), at (-393.164, 21.3356, 16.5925), at (-394.236, 25.5294, 16.5925), at (-391.937, 30.9506, 16.5925), at (-387.875, 33.2491, 16.5925), at (-393.261, 22.5092, 16.5925), at (-383.962, 23.8599, 16.5925), at (-382.533, 26.6246, 16.5925), at (-384.536, 29.9636, 16.5925)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) E02_Ant01_Ring_Q2.face(at (-400.094, 20.2675, 16.5925), at (-405.579, 22.593, 16.5925), at (-407.904, 26.702, 16.5925), at (-405.445, 30.9448, 16.5925), at (-401.202, 33.404, 16.5925), at (-397.093, 31.0786, 16.5925), at (-394.768, 25.594, 16.5925), at (-395.851, 21.3512, 16.5925), at (-396.959, 27.1614, 16.5925), at (-398.405, 30.6611, 16.5925), at (-401.202, 32.1069, 16.5925), at (-404.58, 30.0801, 16.5925)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) E02_Ant01_Ring_Q3.face(at (-397.063, 9.04944, 16.5925), at (-401.125, 6.75086, 16.5925), at (-405.318, 9.18165, 16.5925), at (-407.749, 13.3754, 16.5925), at (-405.451, 17.437, 16.5925), at (-400.029, 19.7356, 16.5925), at (-395.836, 18.6644, 16.5925), at (-394.764, 14.4706, 16.5925), at (-398.24, 16.2603, 16.5925), at (-401.579, 17.5692, 16.5925), at (-405.038, 16.1401, 16.5925), at (-406.467, 13.3754, 16.5925)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) E02_Ant01_Ring_Q4.face(at (-381.096, 13.298, 16.5925), at (-383.555, 9.05517, 16.5925), at (-387.798, 6.59596, 16.5925), at (-391.907, 8.9214, 16.5925), at (-394.232, 14.406, 16.5925), at (-393.149, 18.6488, 16.5925), at (-388.906, 19.7325, 16.5925), at (-383.421, 17.407, 16.5925), at (-387.798, 7.89312, 16.5925), at (-384.42, 9.91994, 16.5925), at (-382.393, 13.298, 16.5925), at (-383.839, 16.095, 16.5925)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) E03_Ant01_Crossover_Bridge.face(at (-342.247, -19.653, 16.5925), at (-340.886, -18.9857, 16.5925), at (-341.553, -20.347, 16.5925), at (-342.914, -21.0143, 16.5925), at (-342.872, -20.7474, 16.5925), at (-341.378, -19.2526, 16.5925), at (-341.9, -20, 16.575)) E03_Ant01_Feed_A_Cu0.face(at (-349.069, -18.4682, 17.3875), at (-347.196, -17.9775, 17.3875), at (-344.149, -17.751, 17.405), at (-346.993, -18.959, 17.3875), at (-344.623, -17.2773, 17.3875), at (-343.923, -14.7041, 17.3875), at (-343.432, -12.8312, 17.3875), at (-342.941, -14.9074, 17.3875), at (-343.261, -17.304, 17.3875), at (-341.435, -19.7712, 17.3875), at (-339.815, -22.0849, 17.3875), at (-342.129, -20.4652, 17.3875)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) E03_Ant01_Feed_A_Cu1.face(at (-339.002, -22.8981, 17.405), at (-338.655, -22.5511, 17.3875), at (-338.857, -23.043, 17.3875), at (-339.349, -23.2452, 17.3875), at (-338.967, -22.9334, 17.3875)) E03_Ant01_Feed_B_Inner_Cu0.face(at (-340.874, -18.2802, 17.3875), at (-339.815, -17.9151, 17.3875), at (-340.527, -18.6272, 17.405), at (-341.42, -19.5195, 17.3875), at (-340.18, -18.9742, 17.3875), at (-341.378, -19.2526, 17.3875)) E03_Ant01_Feed_B_Inner_Cu1.face(at (-339.349, -16.7548, 17.3875), at (-338.857, -16.957, 17.3875), at (-339.002, -17.1019, 17.405), at (-338.655, -17.4489, 17.3875), at (-338.967, -17.0666, 17.3875)) E03_Ant01_Feed_B_Outer.face(at (-349.069, -21.5318, 17.3875), at (-346.993, -21.041, 17.3875), at (-344.596, -21.3614, 17.3875), at (-343.502, -20.9076, 17.3875), at (-342.38, -20.4805, 17.3875), at (-342.808, -21.6016, 17.3875), at (-343.261, -22.696, 17.3875), at (-342.941, -25.0926, 17.3875), at (-343.432, -27.1688, 17.3875), at (-343.923, -25.2959, 17.3875), at (-344.623, -22.7227, 17.3875), at (-347.196, -22.0225, 17.3875)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) E03_Ant01_Ring_Q1.face(at (-331.082, -9.18165, 16.5925), at (-328.651, -13.3754, 16.5925), at (-330.949, -17.437, 16.5925), at (-336.371, -19.7356, 16.5925), at (-340.564, -18.6644, 16.5925), at (-341.636, -14.4706, 16.5925), at (-339.337, -9.04944, 16.5925), at (-335.275, -6.75086, 16.5925), at (-340.661, -17.4908, 16.5925), at (-331.362, -16.1401, 16.5925), at (-329.933, -13.3754, 16.5925), at (-331.936, -10.0364, 16.5925)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) E03_Ant01_Ring_Q2.face(at (-347.494, -19.7325, 16.5925), at (-352.979, -17.407, 16.5925), at (-355.304, -13.298, 16.5925), at (-352.845, -9.05517, 16.5925), at (-348.602, -6.59596, 16.5925), at (-344.493, -8.9214, 16.5925), at (-342.168, -14.406, 16.5925), at (-343.251, -18.6488, 16.5925), at (-344.359, -12.8386, 16.5925), at (-345.805, -9.33892, 16.5925), at (-348.602, -7.89312, 16.5925), at (-351.98, -9.91994, 16.5925)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) E03_Ant01_Ring_Q3.face(at (-344.463, -30.9506, 16.5925), at (-348.525, -33.2491, 16.5925), at (-352.718, -30.8183, 16.5925), at (-355.149, -26.6246, 16.5925), at (-352.851, -22.563, 16.5925), at (-347.429, -20.2644, 16.5925), at (-343.236, -21.3356, 16.5925), at (-342.164, -25.5294, 16.5925), at (-345.64, -23.7397, 16.5925), at (-348.979, -22.4308, 16.5925), at (-352.438, -23.8599, 16.5925), at (-353.867, -26.6246, 16.5925)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) E03_Ant01_Ring_Q4.face(at (-328.496, -26.702, 16.5925), at (-330.955, -30.9448, 16.5925), at (-335.198, -33.404, 16.5925), at (-339.307, -31.0786, 16.5925), at (-341.632, -25.594, 16.5925), at (-340.549, -21.3512, 16.5925), at (-336.306, -20.2675, 16.5925), at (-330.821, -22.593, 16.5925), at (-335.198, -32.1069, 16.5925), at (-331.82, -30.0801, 16.5925), at (-329.793, -26.702, 16.5925), at (-331.239, -23.905, 16.5925)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) E04_Ant01_Crossover_Bridge.face(at (-342.247, 20.347, 16.5925), at (-340.886, 21.0143, 16.5925), at (-341.553, 19.653, 16.5925), at (-342.914, 18.9857, 16.5925), at (-342.872, 19.2526, 16.5925), at (-341.378, 20.7474, 16.5925), at (-341.9, 20, 16.575)) E04_Ant01_Feed_A_Cu0.face(at (-349.069, 21.5318, 17.3875), at (-347.196, 22.0225, 17.3875), at (-344.149, 22.249, 17.405), at (-346.993, 21.041, 17.3875), at (-344.623, 22.7227, 17.3875), at (-343.923, 25.2959, 17.3875), at (-343.432, 27.1688, 17.3875), at (-342.941, 25.0926, 17.3875), at (-343.261, 22.696, 17.3875), at (-341.435, 20.2288, 17.3875), at (-339.815, 17.9151, 17.3875), at (-342.129, 19.5348, 17.3875)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) E04_Ant01_Feed_A_Cu1.face(at (-339.002, 17.1019, 17.405), at (-338.655, 17.4489, 17.3875), at (-338.857, 16.957, 17.3875), at (-339.349, 16.7548, 17.3875), at (-338.967, 17.0666, 17.3875)) E04_Ant01_Feed_B_Inner_Cu0.face(at (-340.874, 21.7198, 17.3875), at (-339.815, 22.0849, 17.3875), at (-340.527, 21.3728, 17.405), at (-341.42, 20.4805, 17.3875), at (-340.18, 21.0258, 17.3875), at (-341.378, 20.7474, 17.3875)) E04_Ant01_Feed_B_Inner_Cu1.face(at (-339.349, 23.2452, 17.3875), at (-338.857, 23.043, 17.3875), at (-339.002, 22.8981, 17.405), at (-338.655, 22.5511, 17.3875), at (-338.967, 22.9334, 17.3875)) E04_Ant01_Feed_B_Outer.face(at (-349.069, 18.4682, 17.3875), at (-346.993, 18.959, 17.3875), at (-344.596, 18.6386, 17.3875), at (-343.502, 19.0924, 17.3875), at (-342.38, 19.5195, 17.3875), at (-342.808, 18.3984, 17.3875), at (-343.261, 17.304, 17.3875), at (-342.941, 14.9074, 17.3875), at (-343.432, 12.8312, 17.3875), at (-343.923, 14.7041, 17.3875), at (-344.623, 17.2773, 17.3875), at (-347.196, 17.9775, 17.3875)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) E04_Ant01_Ring_Q1.face(at (-331.082, 30.8183, 16.5925), at (-328.651, 26.6246, 16.5925), at (-330.949, 22.563, 16.5925), at (-336.371, 20.2644, 16.5925), at (-340.564, 21.3356, 16.5925), at (-341.636, 25.5294, 16.5925), at (-339.337, 30.9506, 16.5925), at (-335.275, 33.2491, 16.5925), at (-340.661, 22.5092, 16.5925), at (-331.362, 23.8599, 16.5925), at (-329.933, 26.6246, 16.5925), at (-331.936, 29.9636, 16.5925)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) E04_Ant01_Ring_Q2.face(at (-347.494, 20.2675, 16.5925), at (-352.979, 22.593, 16.5925), at (-355.304, 26.702, 16.5925), at (-352.845, 30.9448, 16.5925), at (-348.602, 33.404, 16.5925), at (-344.493, 31.0786, 16.5925), at (-342.168, 25.594, 16.5925), at (-343.251, 21.3512, 16.5925), at (-344.359, 27.1614, 16.5925), at (-345.805, 30.6611, 16.5925), at (-348.602, 32.1069, 16.5925), at (-351.98, 30.0801, 16.5925)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) E04_Ant01_Ring_Q3.face(at (-344.463, 9.04944, 16.5925), at (-348.525, 6.75086, 16.5925), at (-352.718, 9.18165, 16.5925), at (-355.149, 13.3754, 16.5925), at (-352.851, 17.437, 16.5925), at (-347.429, 19.7356, 16.5925), at (-343.236, 18.6644, 16.5925), at (-342.164, 14.4706, 16.5925), at (-345.64, 16.2603, 16.5925), at (-348.979, 17.5692, 16.5925), at (-352.438, 16.1401, 16.5925), at (-353.867, 13.3754, 16.5925)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) E04_Ant01_Ring_Q4.face(at (-328.496, 13.298, 16.5925), at (-330.955, 9.05517, 16.5925), at (-335.198, 6.59596, 16.5925), at (-339.307, 8.9214, 16.5925), at (-341.632, 14.406, 16.5925), at (-340.549, 18.6488, 16.5925), at (-336.306, 19.7325, 16.5925), at (-330.821, 17.407, 16.5925), at (-335.198, 7.89312, 16.5925), at (-331.82, 9.91994, 16.5925), at (-329.793, 13.298, 16.5925), at (-331.239, 16.095, 16.5925)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)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 Frequency=0GHz Layers{Layer1{Thickness=0.0254um Material=Ouro_vol_nominal} Layer2{Thickness=4.5um Material=NiP_vol_nominal} Layer3{LayerType=1 Thickness=0 Material=Cobre_vol_Groiss}}
  Open1: Radiation Objects=RadiatingSurface
  E01_A: Lumped Port Objects=E01_A_ext LumpedPortType=Modal Modes{Mode1{IntLine{(-391.39083, -22.509168, 16.575) -> (-391.15598, -22.509168, 16.575)} CharImp=Zpi RenormImp=50ohm}} Impedance=50ohm
  E01_B: Lumped Port Objects=E01_B_ext LumpedPortType=Modal Modes{Mode1{IntLine{(-391.39083, -17.490832, 16.575) -> (-391.15598, -17.490832, 16.575)} CharImp=Zpi RenormImp=50ohm}} Impedance=50ohm
  E02_A: Lumped Port Objects=E02_A_ext LumpedPortType=Modal Modes{Mode1{IntLine{(-391.39083, 17.490832, 16.575) -> (-391.15598, 17.490832, 16.575)} CharImp=Zpi RenormImp=50ohm}} Impedance=50ohm
  E02_B: Lumped Port Objects=E02_B_ext LumpedPortType=Modal Modes{Mode1{IntLine{(-391.39083, 22.509168, 16.575) -> (-391.15598, 22.509168, 16.575)} CharImp=Zpi RenormImp=50ohm}} Impedance=50ohm
  E03_A: Lumped Port Objects=E03_A_ext LumpedPortType=Modal Modes{Mode1{IntLine{(-338.79083, -22.509168, 16.575) -> (-338.55598, -22.509168, 16.575)} CharImp=Zpi RenormImp=50ohm}} Impedance=50ohm
  E03_B: Lumped Port Objects=E03_B_ext LumpedPortType=Modal Modes{Mode1{IntLine{(-338.79083, -17.490832, 16.575) -> (-338.55598, -17.490832, 16.575)} CharImp=Zpi RenormImp=50ohm}} Impedance=50ohm
  E04_A: Lumped Port Objects=E04_A_ext LumpedPortType=Modal Modes{Mode1{IntLine{(-338.79083, 17.490832, 16.575) -> (-338.55598, 17.490832, 16.575)} CharImp=Zpi RenormImp=50ohm}} Impedance=50ohm
  E04_B: Lumped Port Objects=E04_B_ext LumpedPortType=Modal Modes{Mode1{IntLine{(-338.79083, 22.509168, 16.575) -> (-338.55598, 22.509168, 16.575)} CharImp=Zpi RenormImp=50ohm}} Impedance=50ohm
  E05_A: Lumped Port Objects=E05_A_ext LumpedPortType=Modal Modes{Mode1{IntLine{(-286.19083, -22.509168, 16.575) -> (-285.95598, -22.509168, 16.575)} CharImp=Zpi RenormImp=50ohm}} Impedance=50ohm
  E05_B: Lumped Port Objects=E05_B_ext LumpedPortType=Modal Modes{Mode1{IntLine{(-286.19083, -17.490832, 16.575) -> (-285.95598, -17.490832, 16.575)} CharImp=Zpi RenormImp=50ohm}} Impedance=50ohm
  E06_A: Lumped Port Objects=E06_A_ext LumpedPortType=Modal Modes{Mode1{IntLine{(-286.19083, 17.490832, 16.575) -> (-285.95598, 17.490832, 16.575)} CharImp=Zpi RenormImp=50ohm}} Impedance=50ohm
  E06_B: Lumped Port Objects=E06_B_ext LumpedPortType=Modal Modes{Mode1{IntLine{(-286.19083, 22.509168, 16.575) -> (-285.95598, 22.509168, 16.575)} CharImp=Zpi RenormImp=50ohm}} Impedance=50ohm
  E07_A: Lumped Port Objects=E07_A_ext LumpedPortType=Modal Modes{Mode1{IntLine{(-233.59083, -22.509168, 16.575) -> (-233.35598, -22.509168, 16.575)} CharImp=Zpi RenormImp=50ohm}} Impedance=50ohm
  E07_B: Lumped Port Objects=E07_B_ext LumpedPortType=Modal Modes{Mode1{IntLine{(-233.59083, -17.490832, 16.575) -> (-233.35598, -17.490832, 16.575)} CharImp=Zpi RenormImp=50ohm}} Impedance=50ohm
  E08_A: Lumped Port Objects=E08_A_ext LumpedPortType=Modal Modes{Mode1{IntLine{(-233.59083, 17.490832, 16.575) -> (-233.35598, 17.490832, 16.575)} CharImp=Zpi RenormImp=50ohm}} Impedance=50ohm
  E08_B: Lumped Port Objects=E08_B_ext LumpedPortType=Modal Modes{Mode1{IntLine{(-233.59083, 22.509168, 16.575) -> (-233.35598, 22.509168, 16.575)} CharImp=Zpi RenormImp=50ohm}} Impedance=50ohm
  E09_A: Lumped Port Objects=E09_A_ext LumpedPortType=Modal Modes{Mode1{IntLine{(-180.99083, -22.509168, 16.575) -> (-180.75598, -22.509168, 16.575)} CharImp=Zpi RenormImp=50ohm}} Impedance=50ohm
  E09_B: Lumped Port Objects=E09_B_ext LumpedPortType=Modal Modes{Mode1{IntLine{(-180.99083, -17.490832, 16.575) -> (-180.75598, -17.490832, 16.575)} CharImp=Zpi RenormImp=50ohm}} Impedance=50ohm
  E10_A: Lumped Port Objects=E10_A_ext LumpedPortType=Modal Modes{Mode1{IntLine{(-180.99083, 17.490832, 16.575) -> (-180.75598, 17.490832, 16.575)} CharImp=Zpi RenormImp=50ohm}} Impedance=50ohm
  E10_B: Lumped Port Objects=E10_B_ext LumpedPortType=Modal Modes{Mode1{IntLine{(-180.99083, 22.509168, 16.575) -> (-180.75598, 22.509168, 16.575)} CharImp=Zpi RenormImp=50ohm}} Impedance=50ohm
  E11_A: Lumped Port Objects=E11_A_ext LumpedPortType=Modal Modes{Mode1{IntLine{(-128.39083, -22.509168, 16.575) -> (-128.15598, -22.509168, 16.575)} CharImp=Zpi RenormImp=50ohm}} Impedance=50ohm
  E11_B: Lumped Port Objects=E11_B_ext LumpedPortType=Modal Modes{Mode1{IntLine{(-128.39083, -17.490832, 16.575) -> (-128.15598, -17.490832, 16.575)} CharImp=Zpi RenormImp=50ohm}} Impedance=50ohm
  E12_A: Lumped Port Objects=E12_A_ext LumpedPortType=Modal Modes{Mode1{IntLine{(-128.39083, 17.490832, 16.575) -> (-128.15598, 17.490832, 16.575)} CharImp=Zpi RenormImp=50ohm}} Impedance=50ohm
  E12_B: Lumped Port Objects=E12_B_ext LumpedPortType=Modal Modes{Mode1{IntLine{(-128.39083, 22.509168, 16.575) -> (-128.15598, 22.509168, 16.575)} CharImp=Zpi RenormImp=50ohm}} Impedance=50ohm
  E13_A: Lumped Port Objects=E13_A_ext LumpedPortType=Modal Modes{Mode1{IntLine{(-75.790832, -22.509168, 16.575) -> (-75.555976, -22.509168, 16.575)} CharImp=Zpi RenormImp=50ohm}} Impedance=50ohm
  E13_B: Lumped Port Objects=E13_B_ext LumpedPortType=Modal Modes{Mode1{IntLine{(-75.790832, -17.490832, 16.575) -> (-75.555976, -17.490832, 16.575)} CharImp=Zpi RenormImp=50ohm}} Impedance=50ohm
  E14_A: Lumped Port Objects=E14_A_ext LumpedPortType=Modal Modes{Mode1{IntLine{(-75.790832, 17.490832, 16.575) -> (-75.555976, 17.490832, 16.575)} CharImp=Zpi RenormImp=50ohm}} Impedance=50ohm
  E14_B: Lumped Port Objects=E14_B_ext LumpedPortType=Modal Modes{Mode1{IntLine{(-75.790832, 22.509168, 16.575) -> (-75.555976, 22.509168, 16.575)} CharImp=Zpi RenormImp=50ohm}} Impedance=50ohm
  E15_A: Lumped Port Objects=E15_A_ext LumpedPortType=Modal Modes{Mode1{IntLine{(-23.190832, -22.509168, 16.575) -> (-22.955976, -22.509168, 16.575)} CharImp=Zpi RenormImp=50ohm}} Impedance=50ohm
  E15_B: Lumped Port Objects=E15_B_ext LumpedPortType=Modal Modes{Mode1{IntLine{(-23.190832, -17.490832, 16.575) -> (-22.955976, -17.490832, 16.575)} CharImp=Zpi RenormImp=50ohm}} Impedance=50ohm
  E16_A: Lumped Port Objects=E16_A_ext LumpedPortType=Modal Modes{Mode1{IntLine{(-23.190832, 17.490832, 16.575) -> (-22.955976, 17.490832, 16.575)} CharImp=Zpi RenormImp=50ohm}} Impedance=50ohm
  E16_B: Lumped Port Objects=E16_B_ext LumpedPortType=Modal Modes{Mode1{IntLine{(-23.190832, 22.509168, 16.575) -> (-22.955976, 22.509168, 16.575)} CharImp=Zpi RenormImp=50ohm}} Impedance=50ohm
  E17_A: Lumped Port Objects=E17_A_ext LumpedPortType=Modal Modes{Mode1{IntLine{(29.409168, -22.509168, 16.575) -> (29.644024, -22.509168, 16.575)} CharImp=Zpi RenormImp=50ohm}} Impedance=50ohm
  E17_B: Lumped Port Objects=E17_B_ext LumpedPortType=Modal Modes{Mode1{IntLine{(29.409168, -17.490832, 16.575) -> (29.644024, -17.490832, 16.575)} CharImp=Zpi RenormImp=50ohm}} Impedance=50ohm
  E18_A: Lumped Port Objects=E18_A_ext LumpedPortType=Modal Modes{Mode1{IntLine{(29.409168, 17.490832, 16.575) -> (29.644024, 17.490832, 16.575)} CharImp=Zpi RenormImp=50ohm}} Impedance=50ohm
  E18_B: Lumped Port Objects=E18_B_ext LumpedPortType=Modal Modes{Mode1{IntLine{(29.409168, 22.509168, 16.575) -> (29.644024, 22.509168, 16.575)} CharImp=Zpi RenormImp=50ohm}} Impedance=50ohm
  E19_A: Lumped Port Objects=E19_A_ext LumpedPortType=Modal Modes{Mode1{IntLine{(82.009168, -22.509168, 16.575) -> (82.244024, -22.509168, 16.575)} CharImp=Zpi RenormImp=50ohm}} Impedance=50ohm
  E19_B: Lumped Port Objects=E19_B_ext LumpedPortType=Modal Modes{Mode1{IntLine{(82.009168, -17.490832, 16.575) -> (82.244024, -17.490832, 16.575)} CharImp=Zpi RenormImp=50ohm}} Impedance=50ohm
  E20_A: Lumped Port Objects=E20_A_ext LumpedPortType=Modal Modes{Mode1{IntLine{(82.009168, 17.490832, 16.575) -> (82.244024, 17.490832, 16.575)} CharImp=Zpi RenormImp=50ohm}} Impedance=50ohm
  E20_B: Lumped Port Objects=E20_B_ext LumpedPortType=Modal Modes{Mode1{IntLine{(82.009168, 22.509168, 16.575) -> (82.244024, 22.509168, 16.575)} CharImp=Zpi RenormImp=50ohm}} Impedance=50ohm
  E21_A: Lumped Port Objects=E21_A_ext LumpedPortType=Modal Modes{Mode1{IntLine{(134.60917, -22.509168, 16.575) -> (134.84402, -22.509168, 16.575)} CharImp=Zpi RenormImp=50ohm}} Impedance=50ohm
  E21_B: Lumped Port Objects=E21_B_ext LumpedPortType=Modal Modes{Mode1{IntLine{(134.60917, -17.490832, 16.575) -> (134.84402, -17.490832, 16.575)} CharImp=Zpi RenormImp=50ohm}} Impedance=50ohm
  E22_A: Lumped Port Objects=E22_A_ext LumpedPortType=Modal Modes{Mode1{IntLine{(134.60917, 17.490832, 16.575) -> (134.84402, 17.490832, 16.575)} CharImp=Zpi RenormImp=50ohm}} Impedance=50ohm
  E22_B: Lumped Port Objects=E22_B_ext LumpedPortType=Modal Modes{Mode1{IntLine{(134.60917, 22.509168, 16.575) -> (134.84402, 22.509168, 16.575)} CharImp=Zpi RenormImp=50ohm}} Impedance=50ohm
  E23_A: Lumped Port Objects=E23_A_ext LumpedPortType=Modal Modes{Mode1{IntLine{(187.20917, -22.509168, 16.575) -> (187.44402, -22.509168, 16.575)} CharImp=Zpi RenormImp=50ohm}} Impedance=50ohm
  E23_B: Lumped Port Objects=E23_B_ext LumpedPortType=Modal Modes{Mode1{IntLine{(187.20917, -17.490832, 16.575) -> (187.44402, -17.490832, 16.575)} CharImp=Zpi RenormImp=50ohm}} Impedance=50ohm
  E24_A: Lumped Port Objects=E24_A_ext LumpedPortType=Modal Modes{Mode1{IntLine{(187.20917, 17.490832, 16.575) -> (187.44402, 17.490832, 16.575)} CharImp=Zpi RenormImp=50ohm}} Impedance=50ohm
  E24_B: Lumped Port Objects=E24_B_ext LumpedPortType=Modal Modes{Mode1{IntLine{(187.20917, 22.509168, 16.575) -> (187.44402, 22.509168, 16.575)} CharImp=Zpi RenormImp=50ohm}} Impedance=50ohm
  E25_A: Lumped Port Objects=E25_A_ext LumpedPortType=Modal Modes{Mode1{IntLine{(239.80917, -22.509168, 16.575) -> (240.04402, -22.509168, 16.575)} CharImp=Zpi RenormImp=50ohm}} Impedance=50ohm
  E25_B: Lumped Port Objects=E25_B_ext LumpedPortType=Modal Modes{Mode1{IntLine{(239.80917, -17.490832, 16.575) -> (240.04402, -17.490832, 16.575)} CharImp=Zpi RenormImp=50ohm}} Impedance=50ohm
  E26_A: Lumped Port Objects=E26_A_ext LumpedPortType=Modal Modes{Mode1{IntLine{(239.80917, 17.490832, 16.575) -> (240.04402, 17.490832, 16.575)} CharImp=Zpi RenormImp=50ohm}} Impedance=50ohm
  E26_B: Lumped Port Objects=E26_B_ext LumpedPortType=Modal Modes{Mode1{IntLine{(239.80917, 22.509168, 16.575) -> (240.04402, 22.509168, 16.575)} CharImp=Zpi RenormImp=50ohm}} Impedance=50ohm
  E27_A: Lumped Port Objects=E27_A_ext LumpedPortType=Modal Modes{Mode1{IntLine{(292.40917, -22.509168, 16.575) -> (292.64402, -22.509168, 16.575)} CharImp=Zpi RenormImp=50ohm}} Impedance=50ohm
  E27_B: Lumped Port Objects=E27_B_ext LumpedPortType=Modal Modes{Mode1{IntLine{(292.40917, -17.490832, 16.575) -> (292.64402, -17.490832, 16.575)} CharImp=Zpi RenormImp=50ohm}} Impedance=50ohm
  E28_A: Lumped Port Objects=E28_A_ext LumpedPortType=Modal Modes{Mode1{IntLine{(292.40917, 17.490832, 16.575) -> (292.64402, 17.490832, 16.575)} CharImp=Zpi RenormImp=50ohm}} Impedance=50ohm
  E28_B: Lumped Port Objects=E28_B_ext LumpedPortType=Modal Modes{Mode1{IntLine{(292.40917, 22.509168, 16.575) -> (292.64402, 22.509168, 16.575)} CharImp=Zpi RenormImp=50ohm}} Impedance=50ohm
  E29_A: Lumped Port Objects=E29_A_ext LumpedPortType=Modal Modes{Mode1{IntLine{(345.00917, -22.509168, 16.575) -> (345.24402, -22.509168, 16.575)} CharImp=Zpi RenormImp=50ohm}} Impedance=50ohm
  E29_B: Lumped Port Objects=E29_B_ext LumpedPortType=Modal Modes{Mode1{IntLine{(345.00917, -17.490832, 16.575) -> (345.24402, -17.490832, 16.575)} CharImp=Zpi RenormImp=50ohm}} Impedance=50ohm
  E30_A: Lumped Port Objects=E30_A_ext LumpedPortType=Modal Modes{Mode1{IntLine{(345.00917, 17.490832, 16.575) -> (345.24402, 17.490832, 16.575)} CharImp=Zpi RenormImp=50ohm}} Impedance=50ohm
  E30_B: Lumped Port Objects=E30_B_ext LumpedPortType=Modal Modes{Mode1{IntLine{(345.00917, 22.509168, 16.575) -> (345.24402, 22.509168, 16.575)} CharImp=Zpi RenormImp=50ohm}} Impedance=50ohm
  E31_A: Lumped Port Objects=E31_A_ext LumpedPortType=Modal Modes{Mode1{IntLine{(397.60917, -22.509168, 16.575) -> (397.84402, -22.509168, 16.575)} CharImp=Zpi RenormImp=50ohm}} Impedance=50ohm
  E31_B: Lumped Port Objects=E31_B_ext LumpedPortType=Modal Modes{Mode1{IntLine{(397.60917, -17.490832, 16.575) -> (397.84402, -17.490832, 16.575)} CharImp=Zpi RenormImp=50ohm}} Impedance=50ohm
  E32_A: Lumped Port Objects=E32_A_ext LumpedPortType=Modal Modes{Mode1{IntLine{(397.60917, 17.490832, 16.575) -> (397.84402, 17.490832, 16.575)} CharImp=Zpi RenormImp=50ohm}} Impedance=50ohm
  E32_B: Lumped Port Objects=E32_B_ext LumpedPortType=Modal Modes{Mode1{IntLine{(397.60917, 22.509168, 16.575) -> (397.84402, 22.509168, 16.575)} CharImp=Zpi RenormImp=50ohm}} Impedance=50ohm
mesh:
  Vias_curvatura: SurfApproxBased Objects=[E14_Via00_1, E14_Via00_0, E16_Via00_1, E16_Via00_0, E15_Via00_0, E15_Via00_1, E17_Via00_0, E17_Via00_1, E18_Via00_1, E18_Via00_0, E04_Via00_1, E04_Via00_0, E06_Via00_1, E06_Via00_0, E19_Via00_0, E19_Via00_1, E05_Via00_0, E05_Via00_1, E07_Via00_0, E07_Via00_1, E08_Via00_1, E08_Via00_0, E24_Via00_0, E24_Via00_1, E26_Via00_0, E26_Via00_1, E10_Via00_1, E10_Via00_0, E12_Via00_0, E12_Via00_1, E09_Via00_0, E09_Via00_1, E25_Via00_0, E25_Via00_1, E27_Via00_0, E27_Via00_1, E28_Via00_0, E28_Via00_1, E11_Via00_0, E11_Via00_1, E13_Via00_0, E13_Via00_1, E30_Via00_1, E30_Via00_0, E02_Via00_1, E02_Via00_0, E32_Via00_1, E32_Via00_0, E29_Via00_0, E29_Via00_1, E01_Via00_0, E01_Via00_1, E31_Via00_0, E31_Via00_1, E03_Via00_0, E03_Via00_1, E20_Via00_1, E20_Via00_0, E22_Via00_1, E22_Via00_0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] CurvedSurfaceApproxChoice=ManualSettings SurfDev=0.002mm NormalDev=10deg
  Fragmentos_locais: LengthBased Objects=[E15_Ant01_Feed_A_Cu1, E27_Ant01_Feed_B_Inner_Cu1, E13_Ant01_Feed_B_Inner_Cu1, E05_Ant01_Feed_B_Inner_Cu1, E24_Ant01_Feed_B_Inner_Cu1, E08_Ant01_Feed_B_Inner_Cu1, E22_Ant01_Feed_B_Inner_Cu1, E10_Ant01_Feed_B_Inner_Cu1, E23_Ant01_Feed_A_Cu1, E04_Ant01_Feed_A_Cu1, E31_Ant01_Feed_A_Cu1, E15_Ant01_Feed_B_Inner_Cu1, E11_Ant01_Feed_A_Cu1, E05_Ant01_Feed_A_Cu1, E09_Ant01_Feed_A_Cu1, E18_Ant01_Feed_B_Inner_Cu1, E23_Ant01_Feed_B_Inner_Cu1, E14_Ant01_Feed_B_Inner_Cu1, E01_Ant01_Feed_B_Inner_Cu1, E14_Ant01_Feed_A_Cu1, E18_Ant01_Feed_A_Cu1, E20_Ant01_Feed_B_Inner_Cu1, E17_Ant01_Feed_A_Cu1, E19_Ant01_Feed_A_Cu1, E06_Ant01_Feed_A_Cu1, E06_Ant01_Feed_B_Inner_Cu1, E29_Ant01_Feed_B_Inner_Cu1, E24_Ant01_Feed_A_Cu1, E25_Ant01_Feed_B_Inner_Cu1, E09_Ant01_Feed_B_Inner_Cu1, E01_Ant01_Feed_A_Cu1, E28_Ant01_Feed_B_Inner_Cu1, E25_Ant01_Feed_A_Cu1, E29_Ant01_Feed_A_Cu1, E11_Ant01_Feed_B_Inner_Cu1, E30_Ant01_Feed_B_Inner_Cu1, E16_Ant01_Feed_A_Cu1, E16_Ant01_Feed_B_Inner_Cu1, E07_Ant01_Feed_B_Inner_Cu1, E30_Ant01_Feed_A_Cu1, E10_Ant01_Feed_A_Cu1, E08_Ant01_Feed_A_Cu1, E19_Ant01_Feed_B_Inner_Cu1, E13_Ant01_Feed_A_Cu1, E07_Ant01_Feed_A_Cu1, E02_Ant01_Feed_A_Cu1, E26_Ant01_Feed_A_Cu1, E04_Ant01_Feed_B_Inner_Cu1, E20_Ant01_Feed_A_Cu1, E02_Ant01_Feed_B_Inner_Cu1, E17_Ant01_Feed_B_Inner_Cu1, E21_Ant01_Feed_B_Inner_Cu1, E21_Ant01_Feed_A_Cu1, E32_Ant01_Feed_A_Cu1, E26_Ant01_Feed_B_Inner_Cu1, E12_Ant01_Feed_A_Cu1, E32_Ant01_Feed_B_Inner_Cu1, E12_Ant01_Feed_B_Inner_Cu1, E03_Ant01_Feed_B_Inner_Cu1, E28_Ant01_Feed_A_Cu1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] MaxLength=0.06mm
setups:
  Centro: HfssDriven Frequency=5.17GHz MaxDeltaS=0.02 MaximumPasses=6 MinimumPasses=2 MinimumConvergedPasses=2 PercentRefinement=20 BasisOrder=0 PortAccuracy=2 DrivenSolverType="Iterative Solver" IterativeResidual=1e-05 DDMSolverResidual=1e-05 SaveRadFieldsOnly
    sweep Banda17: 5090MHz to 5250MHz step 10MHz; disabled Type=Discrete SaveFields SaveRadFields
source amplitudes:
  E01_A:1, E02_A:1, E03_A:1, E04_A:1, E05_A:1, E06_A:1, E07_A:1, E08_A:1, E09_A:1, E10_A:1, E11_A:1, E12_A:1, E13_A:1, E14_A:1, E15_A:1, E16_A:1, E17_A:1, E18_A:1, E19_A:1, E20_A:1, E21_A:1, E22_A:1, E23_A:1, E24_A:1, E25_A:1, E26_A:1, E27_A:1, E28_A:1, E29_A:1, E30_A:1, E31_A:1, E32_A:1: 0.03125W 0deg
  E01_B:1, E02_B:1, E03_B:1, E04_B:1, E05_B:1, E06_B:1, E07_B:1, E08_B:1, E09_B:1, E10_B:1, E11_B:1, E12_B:1, E13_B:1, E14_B:1, E15_B:1, E16_B:1, E17_B:1, E18_B:1, E19_B:1, E20_B:1, E21_B:1, E22_B:1, E23_B:1, E24_B:1, E25_B:1, E26_B:1, E27_B:1, E28_B:1, E29_B:1, E30_B:1, E31_B:1, E32_B:1: 0W 0deg
radiation setups:
  3D: Infinite Sphere Theta=0deg..180deg step 2deg Phi=-180deg..180deg step 2deg
  Elevation: Infinite Sphere Theta=-180deg..180deg step 1deg Phi=0deg..90deg step 90deg
  Azimuth: Infinite Sphere Theta=90deg..90deg step 0deg Phi=-180deg..180deg step 1deg
  HV: Infinite Sphere Theta=-180deg..180deg step 0.25deg Phi=0deg..90deg step 90deg
