# Ansys Electronics Desktop project, version 2024.2
materials:
  vacuum: permittivity=1
  POM_nom: permittivity=3.4 dielectric_loss_tangent=0.01
  PTFE_terminal: permittivity=2.0363635 dielectric_loss_tangent=0.00027683055
  ZYF300: permittivity=2.94 dielectric_loss_tangent=0.0016
  RO4350B_R01: permittivity=3.66 dielectric_loss_tangent=0.0037
  AL5052: conductivity=20000000
  SAC305: conductivity=7575758
  copper: permeability=0.999991 conductivity=58000000
  NiP_vol_nominal: permeability=1 conductivity=1500000
  Ouro_vol_nominal: permeability=1 conductivity=41000000
  Cobre_vol_Groiss: permeability=1 conductivity=28688604

design PCB_separada (HFSS, HFSS Hybrid Modal Network, model units mm)
geometry:
  Isol_terminal_B4, Isol_terminal_B3, Isol_terminal_B2, Isol_terminal_B1, Isol_terminal_B_IN, Isol_terminal_A4, Isol_terminal_A3, Isol_terminal_A2, Isol_terminal_A1, Isol_terminal_A_IN [PTFE_terminal] = imported_body(D:/dev/EMBRAER/P2M21/R00_Concepcao\divisor_1x4\cad\PTFE_terminal.step)
  PCB [ZYF300] = imported_body(D:/dev/EMBRAER/P2M21/R00_Concepcao\divisor_1x4\cad\ZYF300.step)
  Massa_terminal_B4, Terminal_B4, Massa_terminal_B3, Terminal_B3, Massa_terminal_B2, Terminal_B2, Massa_terminal_B1, Terminal_B1, Massa_terminal_B_IN, Terminal_B_IN, Massa_terminal_A4, Terminal_A4, Massa_terminal_A3, Terminal_A3, Massa_terminal_A2, Terminal_A2, Massa_terminal_A1, Terminal_A1, Massa_terminal_A_IN, Terminal_A_IN [copper] = imported_body(D:/dev/EMBRAER/P2M21/R00_Concepcao\divisor_1x4\cad\copper.step)
  Estrela_B, Estrela_A, GND, Pad_B4, Pad_B3, Pad_B2, Pad_B1, Pad_B_IN, Pad_A4, Pad_A3, Pad_A2, Pad_A1, Pad_A_IN [Cobre_vol_Groiss] = imported_body(D:/dev/EMBRAER/P2M21/R00_Concepcao\divisor_1x4\cad\folha_cu.step)
  A_IN_ext = circle(normal=Z, centre=(0mm, -19.25mm, -0.18mm), radius=1.515mm)
  A_IN_int = circle(normal=Z, centre=(0mm, -19.25mm, -0.18mm), radius=0.525mm)
  A_IN_ext.subtract(A_IN_int)
  A1_ext = circle(normal=Z, centre=(-15.2mm, -19.25mm, -0.18mm), radius=1.515mm)
  A1_int = circle(normal=Z, centre=(-15.2mm, -19.25mm, -0.18mm), radius=0.525mm)
  A1_ext.subtract(A1_int)
  A2_ext = circle(normal=Z, centre=(9.3073157e-16mm, -34.45mm, -0.18mm), radius=1.515mm)
  A2_int = circle(normal=Z, centre=(9.3073157e-16mm, -34.45mm, -0.18mm), radius=0.525mm)
  A2_ext.subtract(A2_int)
  A3_ext = circle(normal=Z, centre=(-2.7921947e-15mm, -4.05mm, -0.18mm), radius=1.515mm)
  A3_int = circle(normal=Z, centre=(-2.7921947e-15mm, -4.05mm, -0.18mm), radius=0.525mm)
  A3_ext.subtract(A3_int)
  A4_ext = circle(normal=Z, centre=(15.2mm, -19.25mm, -0.18mm), radius=1.515mm)
  A4_int = circle(normal=Z, centre=(15.2mm, -19.25mm, -0.18mm), radius=0.525mm)
  A4_ext.subtract(A4_int)
  B_IN_ext = circle(normal=Z, centre=(0mm, 19.25mm, -0.18mm), radius=1.515mm)
  B_IN_int = circle(normal=Z, centre=(0mm, 19.25mm, -0.18mm), radius=0.525mm)
  B_IN_ext.subtract(B_IN_int)
  B1_ext = circle(normal=Z, centre=(-15.2mm, 19.25mm, -0.18mm), radius=1.515mm)
  B1_int = circle(normal=Z, centre=(-15.2mm, 19.25mm, -0.18mm), radius=0.525mm)
  B1_ext.subtract(B1_int)
  B2_ext = circle(normal=Z, centre=(9.3073157e-16mm, 34.45mm, -0.18mm), radius=1.515mm)
  B2_int = circle(normal=Z, centre=(9.3073157e-16mm, 34.45mm, -0.18mm), radius=0.525mm)
  B2_ext.subtract(B2_int)
  B3_ext = circle(normal=Z, centre=(-2.7921947e-15mm, 4.05mm, -0.18mm), radius=1.515mm)
  B3_int = circle(normal=Z, centre=(-2.7921947e-15mm, 4.05mm, -0.18mm), radius=0.525mm)
  B3_ext.subtract(B3_int)
  B4_ext = circle(normal=Z, centre=(15.2mm, 19.25mm, -0.18mm), radius=1.515mm)
  B4_int = circle(normal=Z, centre=(15.2mm, 19.25mm, -0.18mm), radius=0.525mm)
  B4_ext.subtract(B4_int)
  RadiatingSurface [vacuum] = region(absolute_offset=19.646365mm on all sides)
boundaries and excitations:
  ENIG_faces_expostas: Layered Impedance Faces=Estrela_A.face(at (-15.821, -21.0793, 1.5375), at (-15.5769, -21.1447, 1.5375), at (-16.0544, -20.9826, 1.5375), at (0, -19.25, 1.555), at (-15.3263, -21.1777, 1.5375), at (-16.2733, -20.8563, 1.5375), at (-12.914, -21.186, 1.5375), at (-16.4738, -20.7024, 1.5375), at (-10.628, -20.469, 1.5375), at (-16.6524, -20.5238, 1.5375), at (-5.66234, -19.752, 1.5375), at (-16.8063, -20.3233, 1.5375)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) Estrela_B.face(at (1.73263, 3.19556, 1.5375), at (1.82933, 3.42903, 1.5375), at (1.60628, 2.97672, 1.5375), at (0, 19.25, 1.555), at (1.89473, 3.67311, 1.5375), at (1.45245, 2.77624, 1.5375), at (1.92772, 3.92365, 1.5375), at (1.27376, 2.59755, 1.5375), at (1.936, 6.336, 1.5375), at (1.07328, 2.44372, 1.5375), at (1.219, 8.622, 1.5375), at (0.854438, 2.31737, 1.5375)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) GND.face(at (-19, -37.7654, -0.0175), at (-16.4522, -38.1823, -0.0175), at (0, 0, -0.035), at (0, -38.5, -0.0175), at (19, -37.7654, -0.0175), at (-16.4697, -33.8134, -0.0175), at (14.75, -36, -0.0175), at (-19, 0, -0.0175), at (19, 0, -0.0175), at (-16.4522, 33.8177, -0.0175), at (14.75, 36, -0.0175), at (-16.4697, 38.1866, -0.0175)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) Pad_A1.face(at (-15.93, -19.25, -0.0175), at (-15.2, -19.25, -0.035), at (-15.725, -19.25, -0.0175)) Pad_A2.face(at (-0.73, -34.45, -0.0175), at (0, -34.45, -0.035), at (-0.525, -34.45, -0.0175)) Pad_A3.face(at (-0.73, -4.05, -0.0175), at (0, -4.05, -0.035), at (-0.525, -4.05, -0.0175)) Pad_A4.face(at (14.47, -19.25, -0.0175), at (15.2, -19.25, -0.035), at (14.675, -19.25, -0.0175)) Pad_A_IN.face(at (-0.73, -19.25, -0.0175), at (0, -19.25, -0.035), at (-0.525, -19.25, -0.0175)) Pad_B1.face(at (-15.93, 19.25, -0.0175), at (-15.2, 19.25, -0.035), at (-15.725, 19.25, -0.0175)) Pad_B2.face(at (-0.73, 34.45, -0.0175), at (0, 34.45, -0.035), at (-0.525, 34.45, -0.0175)) Pad_B3.face(at (-0.73, 4.05, -0.0175), at (0, 4.05, -0.035), at (-0.525, 4.05, -0.0175)) Pad_B4.face(at (14.47, 19.25, -0.0175), at (15.2, 19.25, -0.035), at (14.675, 19.25, -0.0175)) Pad_B_IN.face(at (-0.73, 19.25, -0.0175), at (0, 19.25, -0.035), at (-0.525, 19.25, -0.0175)) Frequency=0GHz Layers{Layer1{Thickness=0.0254um Material=Ouro_vol_nominal} Layer2{Thickness=4.5um Material=NiP_vol_nominal} Layer3{LayerType=1 Thickness=0 Material=Cobre_vol_Groiss}}
  Open1: Radiation Objects=RadiatingSurface
  A_IN: Lumped Port Objects=A_IN_ext LumpedPortType=Modal Modes{Mode1{IntLine{(0.525, -19.25, -0.18) -> (1.515, -19.25, -0.18)} CharImp=Zpi RenormImp=50ohm}} Impedance=50ohm
  A1: Lumped Port Objects=A1_ext LumpedPortType=Modal Modes{Mode1{IntLine{(-14.675, -19.25, -0.18) -> (-13.685, -19.25, -0.18)} CharImp=Zpi RenormImp=50ohm}} Impedance=50ohm
  A2: Lumped Port Objects=A2_ext LumpedPortType=Modal Modes{Mode1{IntLine{(0.525, -34.45, -0.18) -> (1.515, -34.45, -0.18)} CharImp=Zpi RenormImp=50ohm}} Impedance=50ohm
  A3: Lumped Port Objects=A3_ext LumpedPortType=Modal Modes{Mode1{IntLine{(0.525, -4.05, -0.18) -> (1.515, -4.05, -0.18)} CharImp=Zpi RenormImp=50ohm}} Impedance=50ohm
  A4: Lumped Port Objects=A4_ext LumpedPortType=Modal Modes{Mode1{IntLine{(15.725, -19.25, -0.18) -> (16.715, -19.25, -0.18)} CharImp=Zpi RenormImp=50ohm}} Impedance=50ohm
  B_IN: Lumped Port Objects=B_IN_ext LumpedPortType=Modal Modes{Mode1{IntLine{(0.525, 19.25, -0.18) -> (1.515, 19.25, -0.18)} CharImp=Zpi RenormImp=50ohm}} Impedance=50ohm
  B1: Lumped Port Objects=B1_ext LumpedPortType=Modal Modes{Mode1{IntLine{(-14.675, 19.25, -0.18) -> (-13.685, 19.25, -0.18)} CharImp=Zpi RenormImp=50ohm}} Impedance=50ohm
  B2: Lumped Port Objects=B2_ext LumpedPortType=Modal Modes{Mode1{IntLine{(0.525, 34.45, -0.18) -> (1.515, 34.45, -0.18)} CharImp=Zpi RenormImp=50ohm}} Impedance=50ohm
  B3: Lumped Port Objects=B3_ext LumpedPortType=Modal Modes{Mode1{IntLine{(0.525, 4.05, -0.18) -> (1.515, 4.05, -0.18)} CharImp=Zpi RenormImp=50ohm}} Impedance=50ohm
  B4: Lumped Port Objects=B4_ext LumpedPortType=Modal Modes{Mode1{IntLine{(15.725, 19.25, -0.18) -> (16.715, 19.25, -0.18)} CharImp=Zpi RenormImp=50ohm}} Impedance=50ohm
mesh:
  Linhas_RF_inicial: LengthBased Objects=[Estrela_A, Estrela_B] MaxLength=0.8mm
setups:
  Centro: HfssDriven Frequency=5.17GHz MaxDeltaS=0.02 MaximumPasses=6 MinimumPasses=2 MinimumConvergedPasses=2 PercentRefinement=20 BasisOrder=0 PortAccuracy=2 DrivenSolverType="Iterative Solver" IterativeResidual=1e-05 DDMSolverResidual=1e-05 SaveRadFieldsOnly
    sweep Banda17: 5090MHz to 5250MHz step 10MHz; Type=Discrete
source amplitudes:
  A_IN:1: 1W 0deg
  A1:1, A2:1, A3:1, A4:1, B_IN:1, B1:1, B2:1, B3:1, B4:1: 0W 0deg
radiation setups:
  3D: Infinite Sphere Theta=0deg..180deg step 2deg Phi=-180deg..180deg step 2deg
  Elevation: Infinite Sphere Theta=-180deg..180deg step 1deg Phi=0deg..90deg step 90deg
  Azimuth: Infinite Sphere Theta=90deg..90deg step 0deg Phi=-180deg..180deg step 1deg
