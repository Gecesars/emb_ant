# Ansys Electronics Desktop project, version 2024.2
materials:
  vacuum: permittivity=1
  POM_nom: permittivity=3.4 dielectric_loss_tangent=0.01
  PTFE_terminal: permittivity=2.0363635 dielectric_loss_tangent=0.00027683055
  ZYF300: permittivity=2.94 dielectric_loss_tangent=0.0016
  RO4350B_R01: permittivity=3.66 dielectric_loss_tangent=0.0037
  AL5052: conductivity=20000000
  SAC305: conductivity=7575758
  copper: permeability=0.999991 conductivity=58000000
  NiP_vol_nominal: permeability=1 conductivity=1500000
  Ouro_vol_nominal: permeability=1 conductivity=41000000
  Cobre_vol_Groiss: permeability=1 conductivity=28688604

design Quatro_elementos (HFSS, HFSS Hybrid Modal Network, model units mm)
geometry:
  Refletor_Al2mm [AL5052] = imported_body(D:\dev\EMBRAER\P2M21\R10_Quatro_Verticais\cad\AL5052.step)
  PTFE_B, PTFE_A [PTFE_terminal] = imported_body(D:\dev\EMBRAER\P2M21\R10_Quatro_Verticais\cad\PTFE_terminal.step)
  PCB_RO4350B [RO4350B_R01] = imported_body(D:\dev\EMBRAER\P2M21\R10_Quatro_Verticais\cad\RO4350B_R01.step)
  Solda_B, Solda_A [SAC305] = imported_body(D:\dev\EMBRAER\P2M21\R10_Quatro_Verticais\cad\SAC305.step)
  PTH_B, Blindagem_B, Vivo_B, PTH_A, Blindagem_A, Vivo_A, Via_7, Via_6, Via_5, Via_4, Via_3, Via_2, Via_1, Via_0 [copper] = imported_body(D:\dev\EMBRAER\P2M21\R10_Quatro_Verticais\cad\copper.step)
  F_SIG_B_Cu4, F_SIG_B_Cu3, F_SIG_B_Cu2, F_SIG_B_Cu1, F_SIG_B_Cu0, F_SIG_A_Cu0, B_SIG_B_Cu4, B_SIG_B_Cu3, B_SIG_B_Cu2, B_SIG_B_Cu1, B_SIG_B_Cu0, B_SIG_A_Cu0, B_RET_B_Cu0, B_RET_A_Cu0, B_E4_Q3_Cu0, B_E4_Q2_Cu0, B_E3_Q3_Cu0, B_E3_Q2_Cu0, B_E2_Q3_Cu0, B_E2_Q2_Cu0, B_E1_Q3_Cu0, B_E1_Q2_Cu0 [Cobre_vol_Groiss] = imported_body(D:\dev\EMBRAER\P2M21\R10_Quatro_Verticais\cad\folha_cu.step)
  A_ext = circle(normal=Z, centre=(2.5091684mm, -32mm, -33.39mm), radius=1.515mm)
  A_int = circle(normal=Z, centre=(2.5091684mm, -32mm, -33.39mm), radius=0.45975mm)
  A_ext.subtract(A_int)
  B_ext = circle(normal=Z, centre=(2.5091684mm, 32mm, -33.39mm), radius=1.515mm)
  B_int = circle(normal=Z, centre=(2.5091684mm, 32mm, -33.39mm), radius=0.45975mm)
  B_ext.subtract(B_int)
  RadiatingSurface [vacuum] = region(absolute_offset=19.646365mm on all sides)
boundaries and excitations:
  ENIG_faces_expostas: Layered Impedance Faces=B_E1_Q2_Cu0.face(at (-83.0786, 2.59297, 16.5925), at (-77.594, 0.267527, 16.5925), at (-85.404, 6.70202, 16.5925), at (-73.3512, 1.35121, 16.5925), at (-82.9448, 10.9448, 16.5925), at (-72.2675, 5.59403, 16.5925), at (-78.702, 13.404, 16.5925), at (-74.593, 11.0786, 16.5925), at (-75.905, 10.6611, 16.5925), at (-74.4592, 7.16143, 16.5925), at (-75.7834, 3.7834, 16.5925), at (-79.1614, 2.45921, 16.5925)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) B_E1_Q3_Cu0.face(at (-78.6246, -13.2491, 16.5925), at (-74.563, -10.9506, 16.5925), at (-82.8183, -10.8183, 16.5925), at (-72.2644, -5.52938, 16.5925), at (-85.2491, -6.62457, 16.5925), at (-73.3356, -1.3356, 16.5925), at (-82.9506, -2.56301, 16.5925), at (-77.5294, -0.264435, 16.5925), at (-79.0787, -2.43079, 16.5925), at (-75.7397, -3.73968, 16.5925), at (-74.4308, -7.07867, 16.5925), at (-75.8599, -10.5379, 16.5925)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) B_E2_Q2_Cu0.face(at (-35.0786, 2.59297, 16.5925), at (-29.594, 0.267527, 16.5925), at (-37.404, 6.70202, 16.5925), at (-25.3512, 1.35121, 16.5925), at (-34.9448, 10.9448, 16.5925), at (-24.2675, 5.59403, 16.5925), at (-30.702, 13.404, 16.5925), at (-26.593, 11.0786, 16.5925), at (-27.905, 10.6611, 16.5925), at (-26.4592, 7.16143, 16.5925), at (-27.7834, 3.7834, 16.5925), at (-31.1614, 2.45921, 16.5925)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) B_E2_Q3_Cu0.face(at (-30.6246, -13.2491, 16.5925), at (-26.563, -10.9506, 16.5925), at (-34.8183, -10.8183, 16.5925), at (-24.2644, -5.52938, 16.5925), at (-37.2491, -6.62457, 16.5925), at (-25.3356, -1.3356, 16.5925), at (-34.9506, -2.56301, 16.5925), at (-29.5294, -0.264435, 16.5925), at (-31.0787, -2.43079, 16.5925), at (-27.7397, -3.73968, 16.5925), at (-26.4308, -7.07867, 16.5925), at (-27.8599, -10.5379, 16.5925)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) B_E3_Q2_Cu0.face(at (12.9214, 2.59297, 16.5925), at (18.406, 0.267527, 16.5925), at (10.596, 6.70202, 16.5925), at (22.6488, 1.35121, 16.5925), at (13.0552, 10.9448, 16.5925), at (23.7325, 5.59403, 16.5925), at (17.298, 13.404, 16.5925), at (21.407, 11.0786, 16.5925), at (20.095, 10.6611, 16.5925), at (21.5408, 7.16143, 16.5925), at (20.2166, 3.7834, 16.5925), at (16.8386, 2.45921, 16.5925)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) B_E3_Q3_Cu0.face(at (17.3754, -13.2491, 16.5925), at (21.437, -10.9506, 16.5925), at (13.1817, -10.8183, 16.5925), at (23.7356, -5.52938, 16.5925), at (10.7509, -6.62457, 16.5925), at (22.6644, -1.3356, 16.5925), at (13.0494, -2.56301, 16.5925), at (18.4706, -0.264435, 16.5925), at (16.9213, -2.43079, 16.5925), at (20.2603, -3.73968, 16.5925), at (21.5692, -7.07867, 16.5925), at (20.1401, -10.5379, 16.5925)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) B_E4_Q2_Cu0.face(at (60.9214, 2.59297, 16.5925), at (66.406, 0.267527, 16.5925), at (58.596, 6.70202, 16.5925), at (70.6488, 1.35121, 16.5925), at (61.0552, 10.9448, 16.5925), at (71.7325, 5.59403, 16.5925), at (65.298, 13.404, 16.5925), at (69.407, 11.0786, 16.5925), at (68.095, 10.6611, 16.5925), at (69.5408, 7.16143, 16.5925), at (68.2166, 3.7834, 16.5925), at (64.8386, 2.45921, 16.5925)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) B_E4_Q3_Cu0.face(at (65.3754, -13.2491, 16.5925), at (69.437, -10.9506, 16.5925), at (61.1817, -10.8183, 16.5925), at (71.7356, -5.52938, 16.5925), at (58.7509, -6.62457, 16.5925), at (70.6644, -1.3356, 16.5925), at (61.0494, -2.56301, 16.5925), at (66.4706, -0.264435, 16.5925), at (64.9213, -2.43079, 16.5925), at (68.2603, -3.73968, 16.5925), at (69.5692, -7.07867, 16.5925), at (68.1401, -10.5379, 16.5925)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) B_RET_A_Cu0.face(at (4.31263, -33.9414, 16.5925), at (4.35973, -33.8965, 16.5925), at (4.26444, -33.9851, 16.5925), at (4.40571, -33.8506, 16.5925), at (4.21519, -34.0275, 16.5925), at (4.4411, -33.8136, 16.5925), at (4.16492, -34.0688, 16.5925), at (28.3815, -33.8, 16.5925), at (4.11365, -34.1088, 16.5925), at (52.3092, -26.8715, 16.5925), at (4.06142, -34.1475, 16.5925), at (52.3461, -19.9084, 16.5925)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) B_RET_B_Cu0.face(at (-69.8827, 0.553944, 16.5925), at (-66.4706, 0.264435, 16.5925), at (-70.176, 0.844819, 16.5925), at (-61.0494, 2.56301, 16.5925), at (-70.2438, 0.875771, 16.5925), at (-58.7509, 6.62457, 16.5925), at (-70.3697, 0.939887, 16.5925), at (-61.1817, 10.8183, 16.5925), at (-70.4901, 1.01368, 16.5925), at (-65.3754, 13.2491, 16.5925), at (-70.6043, 1.09669, 16.5925), at (-67.4146, 12.9729, 16.5925)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) B_SIG_A_Cu0.face(at (1.70917, -32, 16.5925), at (1.95917, -32, 16.5925), at (2.50917, -32, 16.575)) B_SIG_B_Cu0.face(at (-70.9857, 1.01434, 16.5925), at (-72.347, 0.347013, 16.5925), at (-71.653, -0.347013, 16.5925), at (-72, 0, 16.575), at (-73.0143, -1.01434, 16.5925), at (-72.9474, -0.747412, 16.5925), at (-71.4526, 0.747412, 16.5925)) B_SIG_B_Cu1.face(at (-23.653, -0.347013, 16.5925), at (-22.9857, 1.01434, 16.5925), at (-25.0143, -1.01434, 16.5925), at (-24, 0, 16.575), at (-24.347, 0.347013, 16.5925), at (-24.9474, -0.747412, 16.5925), at (-23.4526, 0.747412, 16.5925)) B_SIG_B_Cu2.face(at (25.0143, 1.01434, 16.5925), at (23.653, 0.347013, 16.5925), at (24.347, -0.347013, 16.5925), at (24, 0, 16.575), at (22.9857, -1.01434, 16.5925), at (23.0526, -0.747412, 16.5925), at (24.5474, 0.747412, 16.5925)) B_SIG_B_Cu3.face(at (70.9857, -1.01434, 16.5925), at (72.347, -0.347013, 16.5925), at (71.653, 0.347013, 16.5925), at (72, 0, 16.575), at (73.0143, 1.01434, 16.5925), at (71.0526, -0.747412, 16.5925), at (72.5474, 0.747412, 16.5925)) B_SIG_B_Cu4.face(at (1.70917, 32, 16.5925), at (1.95917, 32, 16.5925), at (2.50917, 32, 16.575)) F_SIG_A_Cu0.face(at (1.67696, -31.542, 17.3875), at (1.66677, -31.561, 17.3875), at (1.68846, -31.5217, 17.3875), at (-1.42572, -13.0109, 17.405), at (-1.91663, -31.5698, 17.3875), at (1.70044, -31.5017, 17.3875), at (-5.49547, -31.379, 17.3875), at (1.71291, -31.482, 17.3875), at (-25.0873, -31.1883, 17.3875), at (1.72587, -31.4626, 17.3875), at (-44.6791, -24.8405, 17.3875), at (1.73929, -31.4435, 17.3875)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) F_SIG_B_Cu0.face(at (-72.9076, -1.6016, 17.3875), at (-72.4805, -0.480479, 17.3875), at (-73.3614, -2.69602, 17.3875), at (-75.63, -3.63005, 17.405), at (-73.6016, -0.907572, 17.3875), at (-73.041, -5.09259, 17.3875), at (-74.696, -1.36136, 17.3875), at (-73.5318, -7.16884, 17.3875), at (-77.0926, -1.04104, 17.3875), at (-74.0225, -5.29587, 17.3875), at (-79.1688, -1.53179, 17.3875), at (-74.7227, -2.72271, 17.3875)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) F_SIG_B_Cu1.face(at (-25.3614, -2.69602, 17.3875), at (-24.9076, -1.6016, 17.3875), at (-25.041, -5.09259, 17.3875), at (-27.63, -3.63005, 17.405), at (-24.4805, -0.480479, 17.3875), at (-25.5318, -7.16884, 17.3875), at (-25.6016, -0.907572, 17.3875), at (-26.0225, -5.29587, 17.3875), at (-26.696, -1.36136, 17.3875), at (-26.7227, -2.72271, 17.3875), at (-29.0926, -1.04104, 17.3875), at (-29.2959, -2.02254, 17.3875)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) F_SIG_B_Cu2.face(at (22.6386, -2.69602, 17.3875), at (23.0924, -1.6016, 17.3875), at (22.959, -5.09259, 17.3875), at (20.37, -3.63005, 17.405), at (23.5195, -0.480479, 17.3875), at (22.4682, -7.16884, 17.3875), at (22.3984, -0.907572, 17.3875), at (21.9775, -5.29587, 17.3875), at (21.304, -1.36136, 17.3875), at (21.2773, -2.72271, 17.3875), at (18.9074, -1.04104, 17.3875), at (18.7041, -2.02254, 17.3875)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) F_SIG_B_Cu3.face(at (70.6386, -2.69602, 17.3875), at (71.0924, -1.6016, 17.3875), at (70.959, -5.09259, 17.3875), at (68.37, -3.63005, 17.405), at (71.5195, -0.480479, 17.3875), at (70.4682, -7.16884, 17.3875), at (70.3984, -0.907572, 17.3875), at (69.9775, -5.29587, 17.3875), at (69.304, -1.36136, 17.3875), at (69.2773, -2.72271, 17.3875), at (66.9074, -1.04104, 17.3875), at (66.7041, -2.02254, 17.3875)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) F_SIG_B_Cu4.face(at (-57.3072, 26.8071, 17.3875), at (-60.1189, 22.8094, 17.3875), at (-54.4955, 22.8094, 17.3875), at (1.76176, 16.5417, 17.405), at (-65.2107, 18.8117, 17.3875), at (-53.9955, 18.8117, 17.3875), at (-70.3025, 10.6016, 17.3875), at (-53.4955, 18.621, 17.3875), at (-71.0845, 1.60949, 17.3875), at (-49.9165, 18.4302, 17.3875), at (-71.5195, 0.480479, 17.3875), at (-46.3255, 18.4526, 17.3875)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) Frequency=0GHz Layers{Layer1{Thickness=0.0254um Material=Ouro_vol_nominal} Layer2{Thickness=4.5um Material=NiP_vol_nominal} Layer3{LayerType=1 Thickness=0 Material=Cobre_vol_Groiss}}
  Open1: Radiation Objects=RadiatingSurface
  A: Lumped Port Objects=A_ext LumpedPortType=Modal Modes{Mode1{IntLine{(2.9689184, -32, -33.39) -> (4.0241684, -32, -33.39)} CharImp=Zpi RenormImp=50ohm}} Impedance=50ohm
  B: Lumped Port Objects=B_ext LumpedPortType=Modal Modes{Mode1{IntLine{(2.9689184, 32, -33.39) -> (4.0241684, 32, -33.39)} CharImp=Zpi RenormImp=50ohm}} Impedance=50ohm
mesh:
  initial mesh: MeshMethod=AnsoftClassic
setups:
  Centro: HfssDriven Frequency=5.17GHz MaxDeltaS=0.04 MaximumPasses=6 MinimumPasses=2 MinimumConvergedPasses=2 PercentRefinement=20 BasisOrder=-1 DoLambdaRefine=false PortAccuracy=2 DrivenSolverType="Iterative Solver" IterativeResidual=1e-05 DDMSolverResidual=1e-05 SaveRadFieldsOnly
source amplitudes:
  A:1, B:1: 0.5W 0deg
radiation setups:
  3D: Infinite Sphere Theta=0deg..180deg step 2deg Phi=-180deg..180deg step 2deg
  Elevation: Infinite Sphere Theta=-180deg..180deg step 1deg Phi=0deg..90deg step 90deg
  Azimuth: Infinite Sphere Theta=90deg..90deg step 0deg Phi=-180deg..180deg step 1deg
  HV: Infinite Sphere Theta=-180deg..180deg step 0.25deg Phi=0deg..90deg step 90deg
reports:
  AB_H: dB(RealizedGainTotal), dB(GainTotal), dB(DirTotal), re(rETheta), im(rETheta), re(rEPhi), im(rEPhi) vs Theta on Centro : LastAdaptive, HV [Phi=90deg Freq=5170MHz]
  AB_V: dB(RealizedGainTotal), dB(GainTotal), dB(DirTotal), re(rETheta), im(rETheta), re(rEPhi), im(rEPhi) vs Theta on Centro : LastAdaptive, HV [Phi=0deg Freq=5170MHz]
  A_H: dB(RealizedGainTotal), dB(GainTotal), dB(DirTotal), re(rETheta), im(rETheta), re(rEPhi), im(rEPhi) vs Theta on Centro : LastAdaptive, HV [Phi=90deg Freq=5170MHz]
  A_V: dB(RealizedGainTotal), dB(GainTotal), dB(DirTotal), re(rETheta), im(rETheta), re(rEPhi), im(rEPhi) vs Theta on Centro : LastAdaptive, HV [Phi=0deg Freq=5170MHz]
  B_H: dB(RealizedGainTotal), dB(GainTotal), dB(DirTotal), re(rETheta), im(rETheta), re(rEPhi), im(rEPhi) vs Theta on Centro : LastAdaptive, HV [Phi=90deg Freq=5170MHz]
  B_V: dB(RealizedGainTotal), dB(GainTotal), dB(DirTotal), re(rETheta), im(rETheta), re(rEPhi), im(rEPhi) vs Theta on Centro : LastAdaptive, HV [Phi=0deg Freq=5170MHz]
