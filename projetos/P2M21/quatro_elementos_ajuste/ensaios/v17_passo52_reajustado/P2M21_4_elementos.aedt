# Ansys Electronics Desktop project, version 2024.2
materials:
  vacuum: permittivity=1
  POM_nom: permittivity=3.4 dielectric_loss_tangent=0.01
  PTFE_terminal: permittivity=2.0363635 dielectric_loss_tangent=0.00027683055
  ZYF300: permittivity=2.94 dielectric_loss_tangent=0.0016
  RO4350B_R01: permittivity=3.66 dielectric_loss_tangent=0.0037
  AL5052: conductivity=20000000
  SAC305: conductivity=7575758
  copper: permeability=0.999991 conductivity=58000000
  NiP_vol_nominal: permeability=1 conductivity=1500000
  Ouro_vol_nominal: permeability=1 conductivity=41000000
  Cobre_vol_Groiss: permeability=1 conductivity=28688604

design Quatro_elementos (HFSS, HFSS Hybrid Modal Network, model units mm)
geometry:
  Refletor_Al2mm [AL5052] = imported_body(D:/dev/EMBRAER/P2M21/R11_Divisor_Ajustes/v17_passo52_reajustado\cad\AL5052.step)
  PTFE_B, PTFE_A [PTFE_terminal] = imported_body(D:/dev/EMBRAER/P2M21/R11_Divisor_Ajustes/v17_passo52_reajustado\cad\PTFE_terminal.step)
  PCB_RO4350B [RO4350B_R01] = imported_body(D:/dev/EMBRAER/P2M21/R11_Divisor_Ajustes/v17_passo52_reajustado\cad\RO4350B_R01.step)
  Solda_B, Solda_A [SAC305] = imported_body(D:/dev/EMBRAER/P2M21/R11_Divisor_Ajustes/v17_passo52_reajustado\cad\SAC305.step)
  PTH_B, Blindagem_B, Vivo_B, PTH_A, Blindagem_A, Vivo_A, Via_7, Via_6, Via_5, Via_4, Via_3, Via_2, Via_1, Via_0 [copper] = imported_body(D:/dev/EMBRAER/P2M21/R11_Divisor_Ajustes/v17_passo52_reajustado\cad\copper.step)
  F_SIG_B_Cu4, F_SIG_B_Cu3, F_SIG_B_Cu2, F_SIG_B_Cu1, F_SIG_B_Cu0, F_SIG_A_Cu0, B_SIG_B_Cu4, B_SIG_B_Cu3, B_SIG_B_Cu2, B_SIG_B_Cu1, B_SIG_B_Cu0, B_SIG_A_Cu0, B_RET_B_Cu0, B_RET_A_Cu0, B_E4_Q3_Cu0, B_E4_Q2_Cu0, B_E3_Q3_Cu0, B_E3_Q2_Cu0, B_E2_Q3_Cu0, B_E2_Q2_Cu0, B_E1_Q3_Cu0, B_E1_Q2_Cu0 [Cobre_vol_Groiss] = imported_body(D:/dev/EMBRAER/P2M21/R11_Divisor_Ajustes/v17_passo52_reajustado\cad\folha_cu.step)
  A_ext = circle(normal=Z, centre=(2.5091684mm, -32mm, -33.39mm), radius=1.515mm)
  A_int = circle(normal=Z, centre=(2.5091684mm, -32mm, -33.39mm), radius=0.45975mm)
  A_ext.subtract(A_int)
  B_ext = circle(normal=Z, centre=(2.5091684mm, 32mm, -33.39mm), radius=1.515mm)
  B_int = circle(normal=Z, centre=(2.5091684mm, 32mm, -33.39mm), radius=0.45975mm)
  B_ext.subtract(B_int)
  RadiatingSurface [vacuum] = region(absolute_offset=19.646365mm on all sides)
boundaries and excitations:
  ENIG_faces_expostas: Layered Impedance Faces=B_E1_Q2_Cu0.face(at (-89.0786, 2.59297, 16.5925), at (-83.594, 0.267527, 16.5925), at (-91.404, 6.70202, 16.5925), at (-79.3512, 1.35121, 16.5925), at (-88.9448, 10.9448, 16.5925), at (-78.2675, 5.59403, 16.5925), at (-84.702, 13.404, 16.5925), at (-80.593, 11.0786, 16.5925), at (-81.905, 10.6611, 16.5925), at (-80.4592, 7.16143, 16.5925), at (-81.7834, 3.7834, 16.5925), at (-85.1614, 2.45921, 16.5925)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) B_E1_Q3_Cu0.face(at (-84.6246, -13.2491, 16.5925), at (-80.563, -10.9506, 16.5925), at (-88.8183, -10.8183, 16.5925), at (-78.2644, -5.52938, 16.5925), at (-91.2491, -6.62457, 16.5925), at (-79.3356, -1.3356, 16.5925), at (-88.9506, -2.56301, 16.5925), at (-83.5294, -0.264435, 16.5925), at (-85.0787, -2.43079, 16.5925), at (-81.7397, -3.73968, 16.5925), at (-80.4308, -7.07867, 16.5925), at (-81.8599, -10.5379, 16.5925)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) B_E2_Q2_Cu0.face(at (-37.0786, 2.59297, 16.5925), at (-31.594, 0.267527, 16.5925), at (-39.404, 6.70202, 16.5925), at (-27.3512, 1.35121, 16.5925), at (-36.9448, 10.9448, 16.5925), at (-26.2675, 5.59403, 16.5925), at (-32.702, 13.404, 16.5925), at (-28.593, 11.0786, 16.5925), at (-29.905, 10.6611, 16.5925), at (-28.4592, 7.16143, 16.5925), at (-29.7834, 3.7834, 16.5925), at (-33.1614, 2.45921, 16.5925)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) B_E2_Q3_Cu0.face(at (-32.6246, -13.2491, 16.5925), at (-28.563, -10.9506, 16.5925), at (-36.8183, -10.8183, 16.5925), at (-26.2644, -5.52938, 16.5925), at (-39.2491, -6.62457, 16.5925), at (-27.3356, -1.3356, 16.5925), at (-36.9506, -2.56301, 16.5925), at (-31.5294, -0.264435, 16.5925), at (-33.0787, -2.43079, 16.5925), at (-29.7397, -3.73968, 16.5925), at (-28.4308, -7.07867, 16.5925), at (-29.8599, -10.5379, 16.5925)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) B_E3_Q2_Cu0.face(at (14.9214, 2.59297, 16.5925), at (20.406, 0.267527, 16.5925), at (12.596, 6.70202, 16.5925), at (24.6488, 1.35121, 16.5925), at (15.0552, 10.9448, 16.5925), at (25.7325, 5.59403, 16.5925), at (19.298, 13.404, 16.5925), at (23.407, 11.0786, 16.5925), at (22.095, 10.6611, 16.5925), at (23.5408, 7.16143, 16.5925), at (22.2166, 3.7834, 16.5925), at (18.8386, 2.45921, 16.5925)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) B_E3_Q3_Cu0.face(at (19.3754, -13.2491, 16.5925), at (23.437, -10.9506, 16.5925), at (15.1817, -10.8183, 16.5925), at (25.7356, -5.52938, 16.5925), at (12.7509, -6.62457, 16.5925), at (24.6644, -1.3356, 16.5925), at (15.0494, -2.56301, 16.5925), at (20.4706, -0.264435, 16.5925), at (18.9213, -2.43079, 16.5925), at (22.2603, -3.73968, 16.5925), at (23.5692, -7.07867, 16.5925), at (22.1401, -10.5379, 16.5925)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) B_E4_Q2_Cu0.face(at (66.9214, 2.59297, 16.5925), at (72.406, 0.267527, 16.5925), at (64.596, 6.70202, 16.5925), at (76.6488, 1.35121, 16.5925), at (67.0552, 10.9448, 16.5925), at (77.7325, 5.59403, 16.5925), at (71.298, 13.404, 16.5925), at (75.407, 11.0786, 16.5925), at (74.095, 10.6611, 16.5925), at (75.5408, 7.16143, 16.5925), at (74.2166, 3.7834, 16.5925), at (70.8386, 2.45921, 16.5925)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) B_E4_Q3_Cu0.face(at (71.3754, -13.2491, 16.5925), at (75.437, -10.9506, 16.5925), at (67.1817, -10.8183, 16.5925), at (77.7356, -5.52938, 16.5925), at (64.7509, -6.62457, 16.5925), at (76.6644, -1.3356, 16.5925), at (67.0494, -2.56301, 16.5925), at (72.4706, -0.264435, 16.5925), at (70.9213, -2.43079, 16.5925), at (74.2603, -3.73968, 16.5925), at (75.5692, -7.07867, 16.5925), at (74.1401, -10.5379, 16.5925)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) B_RET_A_Cu0.face(at (25.9356, -5.52938, 16.5925), at (25.934, -8.73638, 16.5925), at (25.7492, -2.13752, 16.5925), at (25.9325, -8.78696, 16.5925), at (25.5648, -1.93751, 16.5925), at (25.7208, -9.04764, 16.5925), at (25.6026, -1.78111, 16.5925), at (25.5092, -15.1296, 16.5925), at (25.6879, -1.49972, 16.5925), at (38.5092, -21, 16.5925), at (25.7922, -1.24558, 16.5925), at (51.5092, -25, 16.5925)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) B_RET_B_Cu0.face(at (-71.4268, 0.264435, 16.5925), at (-67.0494, 2.56301, 16.5925), at (-73.5467, 0.227286, 16.5925), at (-64.7509, 6.62457, 16.5925), at (-73.6484, 0.145069, 16.5925), at (-67.1817, 10.8183, 16.5925), at (-75.3162, 0.1, 16.5925), at (-71.0516, 13.2491, 16.5925), at (-76.6395, 0.383666, 16.5925), at (-72.4908, 14.1246, 16.5925), at (-76.8442, 1.15577, 16.5925), at (-49.4908, 15, 16.5925)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) B_SIG_A_Cu0.face(at (3.30746, -32.0523, 16.5925), at (2.51397, -32, 16.575), at (3.30745, -32.0523, 16.5925), at (3.30917, -32, 16.5925), at (3.30746, -31.9477, 16.5925), at (3.29624, -32.1432, 16.5925), at (3.30745, -31.9477, 16.5925), at (3.29624, -31.8568, 16.5925), at (3.27472, -32.2322, 16.5925), at (3.27472, -32.2322, 16.5925), at (3.27472, -31.7678, 16.5925), at (3.27082, -32.2447, 16.5925)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) B_SIG_B_Cu0.face(at (-79.0143, -1.01434, 16.5925), at (-77.653, -0.347013, 16.5925), at (-78.347, 0.347013, 16.5925), at (-78, 0, 16.575), at (-76.9857, 1.01434, 16.5925), at (-78.9474, -0.747412, 16.5925), at (-77.4526, 0.747412, 16.5925)) B_SIG_B_Cu1.face(at (-27.0143, -1.01434, 16.5925), at (-25.653, -0.347013, 16.5925), at (-26.347, 0.347013, 16.5925), at (-26, 0, 16.575), at (-24.9857, 1.01434, 16.5925), at (-26.9474, -0.747412, 16.5925), at (-25.4526, 0.747412, 16.5925)) B_SIG_B_Cu2.face(at (24.9857, -1.01434, 16.5925), at (26.347, -0.347013, 16.5925), at (25.653, 0.347013, 16.5925), at (26, 0, 16.575), at (27.0143, 1.01434, 16.5925), at (25.0526, -0.747412, 16.5925), at (26.5474, 0.747412, 16.5925)) B_SIG_B_Cu3.face(at (77.653, 0.347013, 16.5925), at (76.9857, -1.01434, 16.5925), at (79.0143, 1.01434, 16.5925), at (78, 0, 16.575), at (78.347, -0.347013, 16.5925), at (77.0526, -0.747412, 16.5925), at (78.5474, 0.747412, 16.5925)) B_SIG_B_Cu4.face(at (3.30746, 31.9477, 16.5925), at (2.51397, 32, 16.575), at (3.30745, 31.9477, 16.5925), at (3.30917, 32, 16.5925), at (3.30746, 32.0523, 16.5925), at (3.29624, 31.8568, 16.5925), at (3.30745, 32.0523, 16.5925), at (3.29624, 32.1432, 16.5925), at (3.27472, 31.7678, 16.5925), at (3.27472, 31.7678, 16.5925), at (3.27472, 32.2322, 16.5925), at (3.27082, 31.7553, 16.5925)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) F_SIG_A_Cu0.face(at (1.74622, -31.4342, 17.3875), at (1.72812, -31.4594, 17.3875), at (1.76515, -31.4095, 17.3875), at (-1.38972, -13.0109, 17.405), at (1.71085, -31.4853, 17.3875), at (1.78486, -31.3855, 17.3875), at (1.69443, -31.5117, 17.3875), at (1.80536, -31.3621, 17.3875), at (1.67889, -31.5386, 17.3875), at (1.82661, -31.3394, 17.3875), at (1.66787, -31.5589, 17.3875), at (1.84859, -31.3174, 17.3875)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) F_SIG_B_Cu0.face(at (-78.4805, -0.480479, 17.3875), at (-79.6016, -0.907572, 17.3875), at (-78.9076, -1.6016, 17.3875), at (-81.63, -3.63005, 17.405), at (-80.696, -1.36136, 17.3875), at (-79.3614, -2.69602, 17.3875), at (-83.0926, -1.04104, 17.3875), at (-79.041, -5.09259, 17.3875), at (-85.1688, -1.53179, 17.3875), at (-79.5318, -7.16884, 17.3875), at (-83.2959, -2.02254, 17.3875), at (-80.0225, -5.29587, 17.3875)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) F_SIG_B_Cu1.face(at (-26.4805, -0.480479, 17.3875), at (-27.6016, -0.907572, 17.3875), at (-26.9076, -1.6016, 17.3875), at (-29.63, -3.63005, 17.405), at (-28.696, -1.36136, 17.3875), at (-27.3614, -2.69602, 17.3875), at (-31.0926, -1.04104, 17.3875), at (-27.041, -5.09259, 17.3875), at (-33.1688, -1.53179, 17.3875), at (-27.5318, -7.16884, 17.3875), at (-31.2959, -2.02254, 17.3875), at (-28.0225, -5.29587, 17.3875)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) F_SIG_B_Cu2.face(at (25.5195, -0.480479, 17.3875), at (24.3984, -0.907572, 17.3875), at (25.0924, -1.6016, 17.3875), at (22.37, -3.63005, 17.405), at (23.304, -1.36136, 17.3875), at (24.6386, -2.69602, 17.3875), at (20.9074, -1.04104, 17.3875), at (24.959, -5.09259, 17.3875), at (18.8312, -1.53179, 17.3875), at (24.4682, -7.16884, 17.3875), at (20.7041, -2.02254, 17.3875), at (23.9775, -5.29587, 17.3875)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) F_SIG_B_Cu3.face(at (77.5195, -0.480479, 17.3875), at (76.3984, -0.907572, 17.3875), at (77.0924, -1.6016, 17.3875), at (74.37, -3.63005, 17.405), at (75.304, -1.36136, 17.3875), at (76.6386, -2.69602, 17.3875), at (72.9074, -1.04104, 17.3875), at (76.959, -5.09259, 17.3875), at (70.8312, -1.53179, 17.3875), at (76.4682, -7.16884, 17.3875), at (72.7041, -2.02254, 17.3875), at (75.9775, -5.29587, 17.3875)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) F_SIG_B_Cu4.face(at (-74.6791, 2.16216, 17.3875), at (-74.6445, 2.66144, 17.3875), at (-75.1438, 1.69746, 17.3875), at (1.76176, 16.5417, 17.405), at (-74.6445, 2.73061, 17.3875), at (-76.3905, 0.915464, 17.3875), at (-74.6791, 9.97674, 17.3875), at (-77.5195, 0.480479, 17.3875), at (-66.0873, 17.1883, 17.3875), at (-77.0845, 1.60949, 17.3875), at (-57.4955, 17.379, 17.3875), at (-76.3025, 10.6016, 17.3875)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) Frequency=0GHz Layers{Layer1{Thickness=0.0254um Material=Ouro_vol_nominal} Layer2{Thickness=4.5um Material=NiP_vol_nominal} Layer3{LayerType=1 Thickness=0 Material=Cobre_vol_Groiss}}
  Open1: Radiation Objects=RadiatingSurface
  A: Lumped Port Objects=A_ext LumpedPortType=Modal Modes{Mode1{IntLine{(2.9689184, -32, -33.39) -> (4.0241684, -32, -33.39)} CharImp=Zpi RenormImp=50ohm}} Impedance=50ohm
  B: Lumped Port Objects=B_ext LumpedPortType=Modal Modes{Mode1{IntLine{(2.9689184, 32, -33.39) -> (4.0241684, 32, -33.39)} CharImp=Zpi RenormImp=50ohm}} Impedance=50ohm
mesh:
  initial mesh: MeshMethod=AnsoftClassic
setups:
  Centro: HfssDriven Frequency=5.17GHz MaxDeltaS=0.05 MaximumPasses=6 MinimumPasses=2 MinimumConvergedPasses=2 PercentRefinement=75 BasisOrder=1 DoLambdaRefine=false PortAccuracy=2 DrivenSolverType="Iterative Solver" IterativeResidual=1e-05 DDMSolverResidual=1e-05
source amplitudes:
  A:1, B:1: 0.5W 0deg
radiation setups:
  3D: Infinite Sphere Theta=0deg..180deg step 2deg Phi=-180deg..180deg step 2deg
  Elevation: Infinite Sphere Theta=-180deg..180deg step 1deg Phi=0deg..90deg step 90deg
  Azimuth: Infinite Sphere Theta=90deg..90deg step 0deg Phi=-180deg..180deg step 1deg
  HV: Infinite Sphere Theta=-180deg..180deg step 0.25deg Phi=0deg..90deg step 90deg
reports:
  AB_H: dB(RealizedGainTotal), dB(GainTotal), dB(DirTotal), re(rETheta), im(rETheta), re(rEPhi), im(rEPhi) vs Theta on Centro : LastAdaptive, HV [Phi=90deg Freq=5170MHz]
  AB_V: dB(RealizedGainTotal), dB(GainTotal), dB(DirTotal), re(rETheta), im(rETheta), re(rEPhi), im(rEPhi) vs Theta on Centro : LastAdaptive, HV [Phi=0deg Freq=5170MHz]
  A_H: dB(RealizedGainTotal), dB(GainTotal), dB(DirTotal), re(rETheta), im(rETheta), re(rEPhi), im(rEPhi) vs Theta on Centro : LastAdaptive, HV [Phi=90deg Freq=5170MHz]
  A_V: dB(RealizedGainTotal), dB(GainTotal), dB(DirTotal), re(rETheta), im(rETheta), re(rEPhi), im(rEPhi) vs Theta on Centro : LastAdaptive, HV [Phi=0deg Freq=5170MHz]
  B_H: dB(RealizedGainTotal), dB(GainTotal), dB(DirTotal), re(rETheta), im(rETheta), re(rEPhi), im(rEPhi) vs Theta on Centro : LastAdaptive, HV [Phi=90deg Freq=5170MHz]
  B_V: dB(RealizedGainTotal), dB(GainTotal), dB(DirTotal), re(rETheta), im(rETheta), re(rEPhi), im(rEPhi) vs Theta on Centro : LastAdaptive, HV [Phi=0deg Freq=5170MHz]
