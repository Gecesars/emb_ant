# Ansys Electronics Desktop project, version 2024.2
materials:
  vacuum: permittivity=1
  Alumina_nominal: permittivity=9.8 dielectric_loss_tangent=0.0001
  ZYF300: permittivity=2.94 dielectric_loss_tangent=0.0016
  PTFE_terminal: permittivity=2.0363635 dielectric_loss_tangent=0.00027683055
  SAC305: conductivity=7575758
  copper: permeability=0.999991 conductivity=58000000
  NiP_vol_nominal: permeability=1 conductivity=1500000
  Ouro_vol_nominal: permeability=1 conductivity=41000000
  Cobre_vol_Groiss: permeability=1 conductivity=28688604

design Duplo1x3_Planar (HFSS, HFSS Hybrid Modal Network, model units mm)
geometry:
  PTFE_R3_B, PTFE_R2_B, PTFE_R1_B, PTFE_IN_B, PTFE_R3_A, PTFE_R2_A, PTFE_R1_A, PTFE_IN_A [PTFE_terminal] = imported_body(D:/dev/EMBRAER/P2S13/R11_Fabricavel_Radome/d00\cad\PTFE_terminal.step)
  Solda_R3_B, Solda_R2_B, Solda_R1_B, Solda_IN_B, Solda_R3_A, Solda_R2_A, Solda_R1_A, Solda_IN_A [SAC305] = imported_body(D:/dev/EMBRAER/P2S13/R11_Fabricavel_Radome/d00\cad\SAC305.step)
  Substrato [ZYF300] = imported_body(D:/dev/EMBRAER/P2S13/R11_Fabricavel_Radome/d00\cad\ZYF300.step)
  Massa_R3_B, Barril_R3_B, Pino_R3_B, Massa_R2_B, Barril_R2_B, Pino_R2_B, Massa_R1_B, Barril_R1_B, Pino_R1_B, Massa_IN_B, Barril_IN_B, Pino_IN_B, Massa_R3_A, Barril_R3_A, Pino_R3_A, Massa_R2_A, Barril_R2_A, Pino_R2_A, Massa_R1_A, Barril_R1_A, Pino_R1_A, Massa_IN_A, Barril_IN_A, Pino_IN_A [copper] = imported_body(D:/dev/EMBRAER/P2S13/R11_Fabricavel_Radome/d00\cad\copper.step)
  Sinal_B, Sinal_A, Terra, Ilha_inferior_R3_B, Ilha_inferior_R2_B, Ilha_inferior_R1_B, Ilha_inferior_IN_B, Ilha_inferior_R3_A, Ilha_inferior_R2_A, Ilha_inferior_R1_A, Ilha_inferior_IN_A [Cobre_vol_Groiss] = imported_body(D:/dev/EMBRAER/P2S13/R11_Fabricavel_Radome/d00\cad\folha_cu.step)
  IN_A_ext = circle(normal=Z, centre=(2.5091684mm, 2.5mm, -0.18mm), radius=1.515mm)
  IN_A_int = circle(normal=Z, centre=(2.5091684mm, 2.5mm, -0.18mm), radius=0.45975mm)
  IN_A_ext.subtract(IN_A_int)
  R1_A_ext = circle(normal=Z, centre=(-93.490832mm, 18mm, -0.18mm), radius=1.515mm)
  R1_A_int = circle(normal=Z, centre=(-93.490832mm, 18mm, -0.18mm), radius=0.45975mm)
  R1_A_ext.subtract(R1_A_int)
  R2_A_ext = circle(normal=Z, centre=(2.5091684mm, 18mm, -0.18mm), radius=1.515mm)
  R2_A_int = circle(normal=Z, centre=(2.5091684mm, 18mm, -0.18mm), radius=0.45975mm)
  R2_A_ext.subtract(R2_A_int)
  R3_A_ext = circle(normal=Z, centre=(98.509168mm, 18mm, -0.18mm), radius=1.515mm)
  R3_A_int = circle(normal=Z, centre=(98.509168mm, 18mm, -0.18mm), radius=0.45975mm)
  R3_A_ext.subtract(R3_A_int)
  IN_B_ext = circle(normal=Z, centre=(2.5091684mm, -2.5mm, -0.18mm), radius=1.515mm)
  IN_B_int = circle(normal=Z, centre=(2.5091684mm, -2.5mm, -0.18mm), radius=0.45975mm)
  IN_B_ext.subtract(IN_B_int)
  R1_B_ext = circle(normal=Z, centre=(-93.490832mm, -18mm, -0.18mm), radius=1.515mm)
  R1_B_int = circle(normal=Z, centre=(-93.490832mm, -18mm, -0.18mm), radius=0.45975mm)
  R1_B_ext.subtract(R1_B_int)
  R2_B_ext = circle(normal=Z, centre=(2.5091684mm, -18mm, -0.18mm), radius=1.515mm)
  R2_B_int = circle(normal=Z, centre=(2.5091684mm, -18mm, -0.18mm), radius=0.45975mm)
  R2_B_ext.subtract(R2_B_int)
  R3_B_ext = circle(normal=Z, centre=(98.509168mm, -18mm, -0.18mm), radius=1.515mm)
  R3_B_int = circle(normal=Z, centre=(98.509168mm, -18mm, -0.18mm), radius=0.45975mm)
  R3_B_ext.subtract(R3_B_int)
  RadiatingSurface [vacuum] = region(absolute_offset=19.34236mm on all sides)
boundaries and excitations:
  ENIG_faces_expostas: Layered Impedance Faces=Ilha_inferior_IN_A.face(at (1.60917, 2.5, -0.0175), at (2.50917, 2.5, -0.035)) Ilha_inferior_IN_B.face(at (1.60917, -2.5, -0.0175), at (2.50917, -2.5, -0.035)) Ilha_inferior_R1_A.face(at (-94.3908, 18, -0.0175), at (-93.4908, 18, -0.035)) Ilha_inferior_R1_B.face(at (-94.3908, -18, -0.0175), at (-93.4908, -18, -0.035)) Ilha_inferior_R2_A.face(at (1.60917, 18, -0.0175), at (2.50917, 18, -0.035)) Ilha_inferior_R2_B.face(at (1.60917, -18, -0.0175), at (2.50917, -18, -0.035)) Ilha_inferior_R3_A.face(at (97.6092, 18, -0.0175), at (98.5092, 18, -0.035)) Ilha_inferior_R3_B.face(at (97.6092, -18, -0.0175), at (98.5092, -18, -0.035)) Sinal_A.face(at (2.50917, 1.6, 1.5375), at (7.7436, 3.94228, 1.5375), at (-2.72527, 3.94228, 1.5375), at (12.0899, 4.79818, 1.5375), at (55.4603, 4.06631, 1.5375), at (99.6368, 4.87234, 1.5375), at (100.443, 11.8392, 1.5375), at (99.926, 18, 1.5375), at (-7.07154, 4.79818, 1.5375), at (97.0923, 18, 1.5375), at (96.5755, 12.9668, 1.5375), at (54.3327, 7.93369, 1.5375)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) Sinal_B.face(at (-93.4908, -18.9, 1.5375), at (-92.074, -18, 1.5375), at (-94.9077, -18, 1.5375), at (-91.5571, -13.6608, 1.5375), at (-90.8632, -8.62766, 1.5375), at (-48.6204, -7.93369, 1.5375), at (-7.07154, -6.96685, 1.5375), at (-6.99581, -6.20731, 1.5375), at (-2.49807, -4.79918, 1.5375), at (2.05818, -3.27885, 1.5375), at (2.20748, -8.02397, 1.5375), at (2.35833, -12.7, 1.5375)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) Terra.face(at (-109.7, 0, -0.0175), at (0, -31.7, -0.0175), at (0, 31.7, -0.0175), at (0, 0, -0.035), at (109.7, 0, -0.0175), at (-95.0058, -18, -0.0175), at (0.994168, -18, -0.0175), at (96.9942, -18, -0.0175), at (0.994168, -2.5, -0.0175), at (-95.0058, 18, -0.0175), at (0.994168, 2.5, -0.0175), at (0.994168, 18, -0.0175)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) Frequency=0GHz Layers{Layer1{Thickness=0.0254um Material=Ouro_vol_nominal} Layer2{Thickness=4.5um Material=NiP_vol_nominal} Layer3{LayerType=1 Thickness=0 Material=Cobre_vol_Groiss}}
  Open1: Radiation Objects=RadiatingSurface
  IN_A: Lumped Port Objects=IN_A_ext LumpedPortType=Modal Modes{Mode1{IntLine{(2.9689184, 2.5, -0.18) -> (4.0241684, 2.5, -0.18)} CharImp=Zpi RenormImp=50ohm}} Impedance=50ohm
  R1_A: Lumped Port Objects=R1_A_ext LumpedPortType=Modal Modes{Mode1{IntLine{(-93.031082, 18, -0.18) -> (-91.975832, 18, -0.18)} CharImp=Zpi RenormImp=50ohm}} Impedance=50ohm
  R2_A: Lumped Port Objects=R2_A_ext LumpedPortType=Modal Modes{Mode1{IntLine{(2.9689184, 18, -0.18) -> (4.0241684, 18, -0.18)} CharImp=Zpi RenormImp=50ohm}} Impedance=50ohm
  R3_A: Lumped Port Objects=R3_A_ext LumpedPortType=Modal Modes{Mode1{IntLine{(98.968918, 18, -0.18) -> (100.02417, 18, -0.18)} CharImp=Zpi RenormImp=50ohm}} Impedance=50ohm
  IN_B: Lumped Port Objects=IN_B_ext LumpedPortType=Modal Modes{Mode1{IntLine{(2.9689184, -2.5, -0.18) -> (4.0241684, -2.5, -0.18)} CharImp=Zpi RenormImp=50ohm}} Impedance=50ohm
  R1_B: Lumped Port Objects=R1_B_ext LumpedPortType=Modal Modes{Mode1{IntLine{(-93.031082, -18, -0.18) -> (-91.975832, -18, -0.18)} CharImp=Zpi RenormImp=50ohm}} Impedance=50ohm
  R2_B: Lumped Port Objects=R2_B_ext LumpedPortType=Modal Modes{Mode1{IntLine{(2.9689184, -18, -0.18) -> (4.0241684, -18, -0.18)} CharImp=Zpi RenormImp=50ohm}} Impedance=50ohm
  R3_B: Lumped Port Objects=R3_B_ext LumpedPortType=Modal Modes{Mode1{IntLine{(98.968918, -18, -0.18) -> (100.02417, -18, -0.18)} CharImp=Zpi RenormImp=50ohm}} Impedance=50ohm
mesh:
  initial mesh: MeshMethod=AnsoftClassic
setups:
  Centro: HfssDriven Frequency=5.17GHz MaxDeltaS=0.05 MaximumPasses=6 MinimumPasses=2 MinimumConvergedPasses=2 PercentRefinement=70 BasisOrder=2 DoLambdaRefine=false PortAccuracy=2 DrivenSolverType="Iterative Solver" IterativeResidual=1e-05 DDMSolverResidual=1e-05 SaveRadFieldsOnly
source amplitudes:
  IN_A:1, IN_B:1: 0.5W 0deg
  R1_A:1, R2_A:1, R3_A:1, R1_B:1, R2_B:1, R3_B:1: 0W 0deg
radiation setups:
  3D: Infinite Sphere Theta=0deg..180deg step 2deg Phi=-180deg..180deg step 2deg
  Elevation: Infinite Sphere Theta=-180deg..180deg step 1deg Phi=0deg..90deg step 90deg
  Azimuth: Infinite Sphere Theta=90deg..90deg step 0deg Phi=-180deg..180deg step 1deg
