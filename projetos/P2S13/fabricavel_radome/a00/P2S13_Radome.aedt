# Ansys Electronics Desktop project, version 2024.2
materials:
  vacuum: permittivity=1
  POM_nom: permittivity=3.4 dielectric_loss_tangent=0.01
  RO4350B_R01: permittivity=3.66 dielectric_loss_tangent=0.0037
  Isola_370HR_nominal: permittivity=3.92 dielectric_loss_tangent=0.025
  ZYF300: permittivity=2.94 dielectric_loss_tangent=0.0016
  PTFE_terminal: permittivity=2.0363635 dielectric_loss_tangent=0.00027683055
  AL5052: conductivity=20000000
  SAC305: conductivity=7575758
  copper: permeability=0.999991 conductivity=58000000
  NiP_vol_nominal: permeability=1 conductivity=1500000
  Ouro_vol_nominal: permeability=1 conductivity=41000000
  Cobre_vol_Groiss: permeability=1 conductivity=28688604

design Conjunto_Radome (HFSS, HFSS Hybrid Modal Network, model units mm)
geometry:
  Radome_FR4_2mm [Isola_370HR_nominal] = imported_body(D:\dev\EMBRAER\P2S13\R11_Fabricavel_Radome\a00\cad\Isola_370HR_nominal.step)
  D_PTFE_R3_B, D_PTFE_R2_B, D_PTFE_R1_B, D_PTFE_IN_B, D_PTFE_R3_A, D_PTFE_R2_A, D_PTFE_R1_A, D_PTFE_IN_A, R3_PTFE_B, R3_PTFE_A, R2_PTFE_B, R2_PTFE_A, R1_PTFE_B, R1_PTFE_A [PTFE_terminal] = imported_body(D:\dev\EMBRAER\P2S13\R11_Fabricavel_Radome\a00\cad\PTFE_terminal.step)
  R3_PCB_RO4350B, R2_PCB_RO4350B, R1_PCB_RO4350B [RO4350B_R01] = imported_body(D:\dev\EMBRAER\P2S13\R11_Fabricavel_Radome\a00\cad\RO4350B_R01.step)
  D_Solda_R3_B, D_Solda_R2_B, D_Solda_R1_B, D_Solda_IN_B, D_Solda_R3_A, D_Solda_R2_A, D_Solda_R1_A, D_Solda_IN_A, R3_Solda_B, R3_Solda_A, R2_Solda_B, R2_Solda_A, R1_Solda_B, R1_Solda_A [SAC305] = imported_body(D:\dev\EMBRAER\P2S13\R11_Fabricavel_Radome\a00\cad\SAC305.step)
  D_Substrato [ZYF300] = imported_body(D:\dev\EMBRAER\P2S13\R11_Fabricavel_Radome\a00\cad\ZYF300.step)
  D_Massa_R3_B, D_Barril_R3_B, D_Pino_R3_B, D_Massa_R2_B, D_Barril_R2_B, D_Pino_R2_B, D_Massa_R1_B, D_Barril_R1_B, D_Pino_R1_B, D_Massa_IN_B, D_Barril_IN_B, D_Pino_IN_B, D_Massa_R3_A, D_Barril_R3_A, D_Pino_R3_A, D_Massa_R2_A, D_Barril_R2_A, D_Pino_R2_A, D_Massa_R1_A, D_Barril_R1_A, D_Pino_R1_A, D_Massa_IN_A, D_Barril_IN_A, D_Pino_IN_A, R3_PTH_B, R3_Blindagem_B, R3_Vivo_B, R3_PTH_A, R3_Blindagem_A, R3_Vivo_A, R3_Via_3, R3_Via_2, R3_Via_1, R3_Via_0, R2_PTH_B, R2_Blindagem_B, R2_Vivo_B, R2_PTH_A, R2_Blindagem_A, R2_Vivo_A, R2_Via_3, R2_Via_2, R2_Via_1, R2_Via_0, R1_PTH_B, R1_Blindagem_B, R1_Vivo_B, R1_PTH_A, R1_Blindagem_A, R1_Vivo_A, R1_Via_3, R1_Via_2, R1_Via_1, R1_Via_0 [copper] = imported_body(D:\dev\EMBRAER\P2S13\R11_Fabricavel_Radome\a00\cad\copper.step)
  D_Sinal_B, D_Sinal_A, D_Terra, D_Ilha_inferior_R3_B, D_Ilha_inferior_R2_B, D_Ilha_inferior_R1_B, D_Ilha_inferior_IN_B, D_Ilha_inferior_R3_A, D_Ilha_inferior_R2_A, D_Ilha_inferior_R1_A, D_Ilha_inferior_IN_A, R3_F_SIG_B_Cu2, R3_F_SIG_B_Cu1, R3_F_SIG_B_Cu0, R3_F_SIG_A_Cu0, R3_B_SIG_B_Cu2, R3_B_SIG_B_Cu1, R3_B_SIG_B_Cu0, R3_B_SIG_A_Cu0, R3_B_RET_B_Cu0, R3_B_RET_A_Cu0, R3_B_E2_Q3_Cu0, R3_B_E2_Q2_Cu0, R3_B_E1_Q3_Cu0, R3_B_E1_Q2_Cu0, R2_F_SIG_B_Cu2, R2_F_SIG_B_Cu1, R2_F_SIG_B_Cu0, R2_F_SIG_A_Cu0, R2_B_SIG_B_Cu2, R2_B_SIG_B_Cu1, R2_B_SIG_B_Cu0, R2_B_SIG_A_Cu0, R2_B_RET_B_Cu0, R2_B_RET_A_Cu0, R2_B_E2_Q3_Cu0, R2_B_E2_Q2_Cu0, R2_B_E1_Q3_Cu0, R2_B_E1_Q2_Cu0, R1_F_SIG_B_Cu2, R1_F_SIG_B_Cu1, R1_F_SIG_B_Cu0, R1_F_SIG_A_Cu0, R1_B_SIG_B_Cu2, R1_B_SIG_B_Cu1, R1_B_SIG_B_Cu0, R1_B_SIG_A_Cu0, R1_B_RET_B_Cu0, R1_B_RET_A_Cu0, R1_B_E2_Q3_Cu0, R1_B_E2_Q2_Cu0, R1_B_E1_Q3_Cu0, R1_B_E1_Q2_Cu0 [Cobre_vol_Groiss] = imported_body(D:\dev\EMBRAER\P2S13\R11_Fabricavel_Radome\a00\cad\folha_cu.step)
  IN_A_ext = circle(normal=Z, centre=(2.5091684mm, -2.5mm, -35.051mm), radius=1.515mm)
  IN_A_int = circle(normal=Z, centre=(2.5091684mm, -2.5mm, -35.051mm), radius=0.45975mm)
  IN_A_ext.subtract(IN_A_int)
  IN_B_ext = circle(normal=Z, centre=(2.5091684mm, 2.5mm, -35.051mm), radius=1.515mm)
  IN_B_int = circle(normal=Z, centre=(2.5091684mm, 2.5mm, -35.051mm), radius=0.45975mm)
  IN_B_ext.subtract(IN_B_int)
  RadiatingSurface [vacuum] = region(absolute_offset=19.646365mm on all sides)
  Refletor_Al2mm [AL5052] = polyline(x=-148mm, yz in mm: (-22.558879, -12.04891) (-30.5, -7.4641016) (-32.363703, -2.9647238) (-28.5, 0) (28.5, 0) (32.363703, -2.9647238) (30.5, -7.4641016) (22.558879, -12.04891) (21.558879, -10.316859) (29.5, -5.7320508) (30.431852, -3.4823619) (28.5, -2) (-28.5, -2) (-30.431852, -3.4823619) (-29.5, -5.7320508) (-21.558879, -10.316859) (-22.558879, -12.04891), closed, covered, Arc from point 1 over 3, Arc from point 4 over 3, Arc from point 9 over 3, Arc from point 12 over 3)
  Refletor_Al2mm.sweep_along_vector((296mm, 0mm, 0mm))
  Furo_Cabo_0 = cylinder(axis=Z, base_centre=(-93.490832mm, -18mm, -100mm), radius=2.1mm, height=120mm)
  Refletor_Al2mm.subtract(Furo_Cabo_0)
  Furo_Cabo_1 = cylinder(axis=Z, base_centre=(-93.490832mm, 18mm, -100mm), radius=2.1mm, height=120mm)
  Refletor_Al2mm.subtract(Furo_Cabo_1)
  Furo_Cabo_2 = cylinder(axis=Z, base_centre=(2.5091684mm, -18mm, -100mm), radius=2.1mm, height=120mm)
  Refletor_Al2mm.subtract(Furo_Cabo_2)
  Furo_Cabo_3 = cylinder(axis=Z, base_centre=(2.5091684mm, 18mm, -100mm), radius=2.1mm, height=120mm)
  Refletor_Al2mm.subtract(Furo_Cabo_3)
  Furo_Cabo_4 = cylinder(axis=Z, base_centre=(98.509168mm, -18mm, -100mm), radius=2.1mm, height=120mm)
  Refletor_Al2mm.subtract(Furo_Cabo_4)
  Furo_Cabo_5 = cylinder(axis=Z, base_centre=(98.509168mm, 18mm, -100mm), radius=2.1mm, height=120mm)
  Refletor_Al2mm.subtract(Furo_Cabo_5)
boundaries and excitations:
  ENIG_faces_expostas: Layered Impedance Faces=D_Ilha_inferior_IN_A.face(at (1.60917, -2.5, -35.2135), at (2.50917, -2.5, -35.196)) D_Ilha_inferior_IN_B.face(at (1.60917, 2.5, -35.2135), at (2.50917, 2.5, -35.196)) D_Ilha_inferior_R1_A.face(at (-94.3908, -18, -35.2135), at (-93.4908, -18, -35.196)) D_Ilha_inferior_R1_B.face(at (-94.3908, 18, -35.2135), at (-93.4908, 18, -35.196)) D_Ilha_inferior_R2_A.face(at (1.60917, -18, -35.2135), at (2.50917, -18, -35.196)) D_Ilha_inferior_R2_B.face(at (1.60917, 18, -35.2135), at (2.50917, 18, -35.196)) D_Ilha_inferior_R3_A.face(at (97.6092, -18, -35.2135), at (98.5092, -18, -35.196)) D_Ilha_inferior_R3_B.face(at (97.6092, 18, -35.2135), at (98.5092, 18, -35.196)) D_Sinal_A.face(at (2.50917, -1.6, -36.7685), at (7.7436, -3.94228, -36.7685), at (-2.72527, -3.94228, -36.7685), at (12.0899, -4.79818, -36.7685), at (55.4603, -4.06631, -36.7685), at (99.6368, -4.87234, -36.7685), at (100.443, -11.8392, -36.7685), at (99.926, -18, -36.7685), at (-7.07154, -4.79818, -36.7685), at (97.0923, -18, -36.7685), at (96.5755, -12.9668, -36.7685), at (54.3327, -7.93369, -36.7685)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) D_Sinal_B.face(at (-93.4908, 18.9, -36.7685), at (-92.074, 18, -36.7685), at (-94.9077, 18, -36.7685), at (-91.5571, 13.6608, -36.7685), at (-90.8632, 8.62766, -36.7685), at (-48.6204, 7.93369, -36.7685), at (-7.07154, 6.96685, -36.7685), at (-6.99581, 6.20731, -36.7685), at (-2.49807, 4.79918, -36.7685), at (2.05818, 3.27885, -36.7685), at (2.20748, 8.02397, -36.7685), at (2.35833, 12.7, -36.7685)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) D_Terra.face(at (-109.7, 0, -35.2135), at (0, 31.7, -35.2135), at (0, -31.7, -35.2135), at (0, 0, -35.196), at (109.7, 0, -35.2135), at (-95.0058, 18, -35.2135), at (0.994168, 18, -35.2135), at (96.9942, 18, -35.2135), at (0.994168, 2.5, -35.2135), at (-95.0058, -18, -35.2135), at (0.994168, -2.5, -35.2135), at (0.994168, -18, -35.2135)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) R1_B_E1_Q2_Cu0.face(at (-131.079, 2.59297, 14.9315), at (-125.594, 0.267527, 14.9315), at (-133.404, 6.70202, 14.9315), at (-121.351, 1.35121, 14.9315), at (-130.945, 10.9448, 14.9315), at (-120.268, 5.59403, 14.9315), at (-126.702, 13.404, 14.9315), at (-122.593, 11.0786, 14.9315), at (-123.905, 10.6611, 14.9315), at (-122.459, 7.16143, 14.9315), at (-123.783, 3.7834, 14.9315), at (-127.161, 2.45921, 14.9315)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) R1_B_E1_Q3_Cu0.face(at (-126.625, -13.2491, 14.9315), at (-122.563, -10.9506, 14.9315), at (-130.818, -10.8183, 14.9315), at (-120.264, -5.52938, 14.9315), at (-133.249, -6.62457, 14.9315), at (-121.336, -1.3356, 14.9315), at (-130.951, -2.56301, 14.9315), at (-125.529, -0.264435, 14.9315), at (-127.079, -2.43079, 14.9315), at (-123.74, -3.73968, 14.9315), at (-122.431, -7.07867, 14.9315), at (-123.86, -10.5379, 14.9315)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) R1_B_E2_Q2_Cu0.face(at (-83.0786, 2.59297, 14.9315), at (-77.594, 0.267527, 14.9315), at (-85.404, 6.70202, 14.9315), at (-73.3512, 1.35121, 14.9315), at (-82.9448, 10.9448, 14.9315), at (-72.2675, 5.59403, 14.9315), at (-78.702, 13.404, 14.9315), at (-74.593, 11.0786, 14.9315), at (-75.905, 10.6611, 14.9315), at (-74.4592, 7.16143, 14.9315), at (-75.7834, 3.7834, 14.9315), at (-79.1614, 2.45921, 14.9315)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) R1_B_E2_Q3_Cu0.face(at (-78.6246, -13.2491, 14.9315), at (-74.563, -10.9506, 14.9315), at (-82.8183, -10.8183, 14.9315), at (-72.2644, -5.52938, 14.9315), at (-85.2491, -6.62457, 14.9315), at (-73.3356, -1.3356, 14.9315), at (-82.9506, -2.56301, 14.9315), at (-77.5294, -0.264435, 14.9315), at (-79.0787, -2.43079, 14.9315), at (-75.7397, -3.73968, 14.9315), at (-74.4308, -7.07867, 14.9315), at (-75.8599, -10.5379, 14.9315)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) R1_B_RET_A_Cu0.face(at (-118.639, -0.383666, 14.9315), at (-118.844, -1.15577, 14.9315), at (-117.316, -0.1, 14.9315), at (-119.666, -1.31053, 14.9315), at (-115.648, -0.145068, 14.9315), at (-120.077, -1.05346, 14.9315), at (-115.545, -0.228832, 14.9315), at (-120.208, -1.24558, 14.9315), at (-113.375, -0.267527, 14.9315), at (-120.312, -1.49972, 14.9315), at (-108.921, -2.59297, 14.9315), at (-120.397, -1.78111, 14.9315)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) R1_B_RET_B_Cu0.face(at (-109.049, 2.56301, 14.9315), at (-106.751, 6.62457, 14.9315), at (-113.427, 0.264435, 14.9315), at (-109.182, 10.8183, 14.9315), at (-115.547, 0.227286, 14.9315), at (-113.052, 13.2491, 14.9315), at (-115.648, 0.145069, 14.9315), at (-114.491, 14.1246, 14.9315), at (-117.316, 0.1, 14.9315), at (-93.4908, 15, 14.9315), at (-118.639, 0.383666, 14.9315), at (-72.4908, 12.1296, 14.9315)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) R1_B_SIG_A_Cu0.face(at (-92.6925, -18.0523, 14.9315), at (-93.486, -18, 14.914), at (-92.6925, -18.0523, 14.9315), at (-92.6908, -18, 14.9315), at (-92.6925, -17.9477, 14.9315), at (-92.7038, -18.1432, 14.9315), at (-92.6925, -17.9477, 14.9315), at (-92.7038, -17.8568, 14.9315), at (-92.7253, -18.2322, 14.9315), at (-92.7253, -18.2322, 14.9315), at (-92.7253, -17.7678, 14.9315), at (-92.7292, -18.2447, 14.9315)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) R1_B_SIG_B_Cu0.face(at (-119.653, -0.347013, 14.9315), at (-118.986, 1.01434, 14.9315), at (-121.014, -1.01434, 14.9315), at (-120, 0, 14.914), at (-120.347, 0.347013, 14.9315), at (-120.947, -0.747412, 14.9315), at (-119.453, 0.747412, 14.9315)) R1_B_SIG_B_Cu1.face(at (-73.0143, -1.01434, 14.9315), at (-71.653, -0.347013, 14.9315), at (-72.347, 0.347013, 14.9315), at (-72, 0, 14.914), at (-70.9857, 1.01434, 14.9315), at (-72.9474, -0.747412, 14.9315), at (-71.4526, 0.747412, 14.9315)) R1_B_SIG_B_Cu2.face(at (-92.6925, 17.9477, 14.9315), at (-93.486, 18, 14.914), at (-92.6925, 17.9477, 14.9315), at (-92.6908, 18, 14.9315), at (-92.6925, 18.0523, 14.9315), at (-92.7038, 17.8568, 14.9315), at (-92.6925, 18.0523, 14.9315), at (-92.7038, 18.1432, 14.9315), at (-92.7253, 17.7678, 14.9315), at (-92.7253, 17.7678, 14.9315), at (-92.7253, 18.2322, 14.9315), at (-92.7292, 17.7553, 14.9315)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) R1_F_SIG_A_Cu0.face(at (-94.3852, -17.68, 15.7265), at (-94.3952, -17.7094, 15.7265), at (-94.3742, -17.6509, 15.7265), at (-97.7137, -5.96894, 15.744), at (-94.4003, -17.7254, 15.7265), at (-94.3623, -17.6222, 15.7265), at (-100.116, -17.7266, 15.7265), at (-94.3495, -17.5939, 15.7265), at (-105.831, -17.4575, 15.7265), at (-94.3358, -17.566, 15.7265), at (-111.255, -17.1883, 15.7265), at (-94.3211, -17.5386, 15.7265)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) R1_F_SIG_B_Cu0.face(at (-121.602, -0.907572, 15.7265), at (-122.696, -1.36136, 15.7265), at (-120.48, -0.480479, 15.7265), at (-123.63, -3.63005, 15.744), at (-125.093, -1.04104, 15.7265), at (-120.908, -1.6016, 15.7265), at (-127.169, -1.53179, 15.7265), at (-121.361, -2.69602, 15.7265), at (-125.296, -2.02254, 15.7265), at (-121.041, -5.09259, 15.7265), at (-122.723, -2.72271, 15.7265), at (-121.532, -7.16884, 15.7265)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) R1_F_SIG_B_Cu1.face(at (-73.6016, -0.907572, 15.7265), at (-74.696, -1.36136, 15.7265), at (-72.4805, -0.480479, 15.7265), at (-75.63, -3.63005, 15.744), at (-77.0926, -1.04104, 15.7265), at (-72.9076, -1.6016, 15.7265), at (-79.1688, -1.53179, 15.7265), at (-73.3614, -2.69602, 15.7265), at (-77.2959, -2.02254, 15.7265), at (-73.041, -5.09259, 15.7265), at (-74.7227, -2.72271, 15.7265), at (-73.5318, -7.16884, 15.7265)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) R1_F_SIG_B_Cu2.face(at (-118.303, 10.6016, 15.7265), at (-119.085, 1.60949, 15.7265), at (-112.067, 18.8117, 15.7265), at (-94.2382, 9.54173, 15.744), at (-119.52, 0.480479, 15.7265), at (-105.831, 18.5425, 15.7265), at (-118.391, 0.915464, 15.7265), at (-100.116, 18.2734, 15.7265), at (-117.144, 1.69746, 15.7265), at (-94.4003, 18.2746, 15.7265), at (-116.679, 2.16216, 15.7265), at (-94.3952, 18.2906, 15.7265)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) R2_B_E1_Q2_Cu0.face(at (-35.0786, 2.59297, 14.9315), at (-29.594, 0.267527, 14.9315), at (-37.404, 6.70202, 14.9315), at (-25.3512, 1.35121, 14.9315), at (-34.9448, 10.9448, 14.9315), at (-24.2675, 5.59403, 14.9315), at (-30.702, 13.404, 14.9315), at (-26.593, 11.0786, 14.9315), at (-27.905, 10.6611, 14.9315), at (-26.4592, 7.16143, 14.9315), at (-27.7834, 3.7834, 14.9315), at (-31.1614, 2.45921, 14.9315)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) R2_B_E1_Q3_Cu0.face(at (-30.6246, -13.2491, 14.9315), at (-26.563, -10.9506, 14.9315), at (-34.8183, -10.8183, 14.9315), at (-24.2644, -5.52938, 14.9315), at (-37.2491, -6.62457, 14.9315), at (-25.3356, -1.3356, 14.9315), at (-34.9506, -2.56301, 14.9315), at (-29.5294, -0.264435, 14.9315), at (-31.0787, -2.43079, 14.9315), at (-27.7397, -3.73968, 14.9315), at (-26.4308, -7.07867, 14.9315), at (-27.8599, -10.5379, 14.9315)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) R2_B_E2_Q2_Cu0.face(at (12.9214, 2.59297, 14.9315), at (18.406, 0.267527, 14.9315), at (10.596, 6.70202, 14.9315), at (22.6488, 1.35121, 14.9315), at (13.0552, 10.9448, 14.9315), at (23.7325, 5.59403, 14.9315), at (17.298, 13.404, 14.9315), at (21.407, 11.0786, 14.9315), at (20.095, 10.6611, 14.9315), at (21.5408, 7.16143, 14.9315), at (20.2166, 3.7834, 14.9315), at (16.8386, 2.45921, 14.9315)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) R2_B_E2_Q3_Cu0.face(at (17.3754, -13.2491, 14.9315), at (21.437, -10.9506, 14.9315), at (13.1817, -10.8183, 14.9315), at (23.7356, -5.52938, 14.9315), at (10.7509, -6.62457, 14.9315), at (22.6644, -1.3356, 14.9315), at (13.0494, -2.56301, 14.9315), at (18.4706, -0.264435, 14.9315), at (16.9213, -2.43079, 14.9315), at (20.2603, -3.73968, 14.9315), at (21.5692, -7.07867, 14.9315), at (20.1401, -10.5379, 14.9315)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) R2_B_RET_A_Cu0.face(at (-22.6395, -0.383666, 14.9315), at (-22.8442, -1.15577, 14.9315), at (-21.3162, -0.1, 14.9315), at (-23.6663, -1.31053, 14.9315), at (-19.6484, -0.145068, 14.9315), at (-24.0766, -1.05346, 14.9315), at (-19.545, -0.228832, 14.9315), at (-24.2078, -1.24558, 14.9315), at (-17.3746, -0.267527, 14.9315), at (-24.3121, -1.49972, 14.9315), at (-12.9214, -2.59297, 14.9315), at (-24.3974, -1.78111, 14.9315)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) R2_B_RET_B_Cu0.face(at (-13.0494, 2.56301, 14.9315), at (-10.7509, 6.62457, 14.9315), at (-17.4268, 0.264435, 14.9315), at (-13.1817, 10.8183, 14.9315), at (-19.5467, 0.227286, 14.9315), at (-17.0516, 13.2491, 14.9315), at (-19.6484, 0.145069, 14.9315), at (-18.4908, 14.1246, 14.9315), at (-21.3162, 0.1, 14.9315), at (2.50917, 15, 14.9315), at (-22.6395, 0.383666, 14.9315), at (23.5092, 12.1296, 14.9315)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) R2_B_SIG_A_Cu0.face(at (3.30746, -18.0523, 14.9315), at (2.51397, -18, 14.914), at (3.30745, -18.0523, 14.9315), at (3.30917, -18, 14.9315), at (3.30746, -17.9477, 14.9315), at (3.29624, -18.1432, 14.9315), at (3.30745, -17.9477, 14.9315), at (3.29624, -17.8568, 14.9315), at (3.27472, -18.2322, 14.9315), at (3.27472, -18.2322, 14.9315), at (3.27472, -17.7678, 14.9315), at (3.27082, -18.2447, 14.9315)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) R2_B_SIG_B_Cu0.face(at (-23.653, -0.347013, 14.9315), at (-22.9857, 1.01434, 14.9315), at (-25.0143, -1.01434, 14.9315), at (-24, 0, 14.914), at (-24.347, 0.347013, 14.9315), at (-24.9474, -0.747412, 14.9315), at (-23.4526, 0.747412, 14.9315)) R2_B_SIG_B_Cu1.face(at (22.9857, -1.01434, 14.9315), at (24.347, -0.347013, 14.9315), at (23.653, 0.347013, 14.9315), at (24, 0, 14.914), at (25.0143, 1.01434, 14.9315), at (23.0526, -0.747412, 14.9315), at (24.5474, 0.747412, 14.9315)) R2_B_SIG_B_Cu2.face(at (3.30746, 17.9477, 14.9315), at (2.51397, 18, 14.914), at (3.30745, 17.9477, 14.9315), at (3.30917, 18, 14.9315), at (3.30746, 18.0523, 14.9315), at (3.29624, 17.8568, 14.9315), at (3.30745, 18.0523, 14.9315), at (3.29624, 18.1432, 14.9315), at (3.27472, 17.7678, 14.9315), at (3.27472, 17.7678, 14.9315), at (3.27472, 18.2322, 14.9315), at (3.27082, 17.7553, 14.9315)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) R2_F_SIG_A_Cu0.face(at (1.61482, -17.68, 15.7265), at (1.60483, -17.7094, 15.7265), at (1.62577, -17.6509, 15.7265), at (-1.71372, -5.96894, 15.744), at (1.59973, -17.7254, 15.7265), at (1.63767, -17.6222, 15.7265), at (-4.11578, -17.7266, 15.7265), at (1.65049, -17.5939, 15.7265), at (-9.83094, -17.4575, 15.7265), at (1.66424, -17.566, 15.7265), at (-15.255, -17.1883, 15.7265), at (1.67889, -17.5386, 15.7265)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) R2_F_SIG_B_Cu0.face(at (-25.6016, -0.907572, 15.7265), at (-26.696, -1.36136, 15.7265), at (-24.4805, -0.480479, 15.7265), at (-27.63, -3.63005, 15.744), at (-29.0926, -1.04104, 15.7265), at (-24.9076, -1.6016, 15.7265), at (-31.1688, -1.53179, 15.7265), at (-25.3614, -2.69602, 15.7265), at (-29.2959, -2.02254, 15.7265), at (-25.041, -5.09259, 15.7265), at (-26.7227, -2.72271, 15.7265), at (-25.5318, -7.16884, 15.7265)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) R2_F_SIG_B_Cu1.face(at (22.3984, -0.907572, 15.7265), at (21.304, -1.36136, 15.7265), at (23.5195, -0.480479, 15.7265), at (20.37, -3.63005, 15.744), at (18.9074, -1.04104, 15.7265), at (23.0924, -1.6016, 15.7265), at (16.8312, -1.53179, 15.7265), at (22.6386, -2.69602, 15.7265), at (18.7041, -2.02254, 15.7265), at (22.959, -5.09259, 15.7265), at (21.2773, -2.72271, 15.7265), at (22.4682, -7.16884, 15.7265)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) R2_F_SIG_B_Cu2.face(at (-22.3025, 10.6016, 15.7265), at (-23.0845, 1.60949, 15.7265), at (-16.0667, 18.8117, 15.7265), at (1.76176, 9.54173, 15.744), at (-23.5195, 0.480479, 15.7265), at (-9.83094, 18.5425, 15.7265), at (-22.3905, 0.915464, 15.7265), at (-4.11578, 18.2734, 15.7265), at (-21.1438, 1.69746, 15.7265), at (1.59973, 18.2746, 15.7265), at (-20.6791, 2.16216, 15.7265), at (1.60483, 18.2906, 15.7265)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) R3_B_E1_Q2_Cu0.face(at (60.9214, 2.59297, 14.9315), at (66.406, 0.267527, 14.9315), at (58.596, 6.70202, 14.9315), at (70.6488, 1.35121, 14.9315), at (61.0552, 10.9448, 14.9315), at (71.7325, 5.59403, 14.9315), at (65.298, 13.404, 14.9315), at (69.407, 11.0786, 14.9315), at (68.095, 10.6611, 14.9315), at (69.5408, 7.16143, 14.9315), at (68.2166, 3.7834, 14.9315), at (64.8386, 2.45921, 14.9315)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)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 Frequency=0GHz Layers{Layer1{Thickness=0.0254um Material=Ouro_vol_nominal} Layer2{Thickness=4.5um Material=NiP_vol_nominal} Layer3{LayerType=1 Thickness=0 Material=Cobre_vol_Groiss}}
  Open1: Radiation Objects=RadiatingSurface
  IN_A: Lumped Port Objects=IN_A_ext LumpedPortType=Modal Modes{Mode1{IntLine{(2.9689184, -2.5, -35.051) -> (4.0241684, -2.5, -35.051)} CharImp=Zpi RenormImp=50ohm}} Impedance=50ohm
  IN_B: Lumped Port Objects=IN_B_ext LumpedPortType=Modal Modes{Mode1{IntLine{(2.9689184, 2.5, -35.051) -> (4.0241684, 2.5, -35.051)} CharImp=Zpi RenormImp=50ohm}} Impedance=50ohm
mesh:
  initial mesh: MeshMethod=AnsoftClassic
setups:
  Centro: HfssDriven Frequency=5.17GHz MaxDeltaS=0.05 MaximumPasses=6 MinimumPasses=2 MinimumConvergedPasses=2 PercentRefinement=50 BasisOrder=2 DoLambdaRefine=false PortAccuracy=2 DrivenSolverType="Iterative Solver" IterativeResidual=1e-05 DDMSolverResidual=1e-05 SaveRadFieldsOnly ExpressionCache{CacheItem{Title=P2S13_Campo_00 Expression=dB(RealizedGainTotal) Intrinsics="Phi='90deg' Theta='0deg'" TraceID=85 ReportType=3} CacheItem{Title=P2S13_Campo_01 Expression=dB(RealizedGainTotal) Intrinsics="Phi='90deg' Theta='-50deg'" TraceID=86 ReportType=3} CacheItem{Title=P2S13_Campo_02 Expression=dB(RealizedGainTotal) Intrinsics="Phi='90deg' Theta='50deg'" TraceID=87 ReportType=3} CacheItem{Title=P2S13_Campo_03 Expression=dB(RealizedGainTotal) Intrinsics="Phi='90deg' Theta='-60deg'" TraceID=88 ReportType=3} CacheItem{Title=P2S13_Campo_04 Expression=dB(RealizedGainTotal) Intrinsics="Phi='90deg' Theta='60deg'" TraceID=89 ReportType=3} CacheItem{Title=P2S13_Campo_05 Expression=dB(RealizedGainTotal) Intrinsics="Phi='0deg' Theta='-8deg'" TraceID=90 ReportType=3} CacheItem{Title=P2S13_Campo_06 Expression=dB(RealizedGainTotal) Intrinsics="Phi='0deg' Theta='8deg'" TraceID=91 ReportType=3} CacheItem{Title=P2S13_Campo_07 Expression=dB(RealizedGainTotal) Intrinsics="Phi='0deg' Theta='-10deg'" TraceID=92 ReportType=3} CacheItem{Title=P2S13_Campo_08 Expression=dB(RealizedGainTotal) Intrinsics="Phi='0deg' Theta='10deg'" TraceID=93 ReportType=3}}
source amplitudes:
  IN_A:1, IN_B:1: 0.5W 0deg
radiation setups:
  3D: Infinite Sphere Theta=0deg..180deg step 2deg Phi=-180deg..180deg step 2deg
  Elevation: Infinite Sphere Theta=-180deg..180deg step 1deg Phi=0deg..90deg step 90deg
  Azimuth: Infinite Sphere Theta=90deg..90deg step 0deg Phi=-180deg..180deg step 1deg
  HV: Infinite Sphere Theta=-180deg..180deg step 0.25deg Phi=0deg..90deg step 90deg
  V_fino: Infinite Sphere Theta=-12deg..12deg step 0.01deg Phi=0deg..0deg step 1deg
  Potencia: Infinite Sphere Theta=0deg..180deg step 2deg Phi=0deg..360deg step 2deg
reports:
  ALL_H: dB(RealizedGainTotal), dB(GainTotal), dB(DirTotal), re(rETheta), im(rETheta), re(rEPhi), im(rEPhi) vs Theta on Centro : LastAdaptive, HV [Phi=90deg Freq=5170MHz]
  ALL_V: dB(RealizedGainTotal), dB(GainTotal), dB(DirTotal), re(rETheta), im(rETheta), re(rEPhi), im(rEPhi) vs Theta on Centro : LastAdaptive, HV [Phi=0deg Freq=5170MHz]
  POL_A_H: dB(RealizedGainTotal), dB(GainTotal), dB(DirTotal), re(rETheta), im(rETheta), re(rEPhi), im(rEPhi) vs Theta on Centro : LastAdaptive, HV [Phi=90deg Freq=5170MHz]
  POL_A_V: dB(RealizedGainTotal), dB(GainTotal), dB(DirTotal), re(rETheta), im(rETheta), re(rEPhi), im(rEPhi) vs Theta on Centro : LastAdaptive, HV [Phi=0deg Freq=5170MHz]
  POL_B_H: dB(RealizedGainTotal), dB(GainTotal), dB(DirTotal), re(rETheta), im(rETheta), re(rEPhi), im(rEPhi) vs Theta on Centro : LastAdaptive, HV [Phi=90deg Freq=5170MHz]
  POL_B_V: dB(RealizedGainTotal), dB(GainTotal), dB(DirTotal), re(rETheta), im(rETheta), re(rEPhi), im(rEPhi) vs Theta on Centro : LastAdaptive, HV [Phi=0deg Freq=5170MHz]
  IN_A_H: dB(RealizedGainTotal), dB(GainTotal), dB(DirTotal), re(rETheta), im(rETheta), re(rEPhi), im(rEPhi) vs Theta on Centro : LastAdaptive, HV [Phi=90deg Freq=5170MHz]
  IN_A_V: dB(RealizedGainTotal), dB(GainTotal), dB(DirTotal), re(rETheta), im(rETheta), re(rEPhi), im(rEPhi) vs Theta on Centro : LastAdaptive, HV [Phi=0deg Freq=5170MHz]
  IN_B_H: dB(RealizedGainTotal), dB(GainTotal), dB(DirTotal), re(rETheta), im(rETheta), re(rEPhi), im(rEPhi) vs Theta on Centro : LastAdaptive, HV [Phi=90deg Freq=5170MHz]
  IN_B_V: dB(RealizedGainTotal), dB(GainTotal), dB(DirTotal), re(rETheta), im(rETheta), re(rEPhi), im(rEPhi) vs Theta on Centro : LastAdaptive, HV [Phi=0deg Freq=5170MHz]
  ALL_V_fino: dB(RealizedGainTotal), re(rETheta), im(rETheta), re(rEPhi), im(rEPhi) vs Theta on Centro : LastAdaptive, V_fino [Phi=0deg Freq=5170MHz]
