# Ansys Electronics Desktop project, version 2024.2
materials:
  vacuum: permittivity=1
  Alumina_nominal: permittivity=9.8 dielectric_loss_tangent=0.0001
  ZYF300: permittivity=2.94 dielectric_loss_tangent=0.0016
  PTFE_terminal: permittivity=2.0363635 dielectric_loss_tangent=0.00027683055
  SAC305: conductivity=7575758
  copper: permeability=0.999991 conductivity=58000000
  NiP_vol_nominal: permeability=1 conductivity=1500000
  Ouro_vol_nominal: permeability=1 conductivity=41000000
  Cobre_vol_Groiss: permeability=1 conductivity=28688604

design Duplo1x3_Planar (HFSS, HFSS Hybrid Modal Network, model units mm)
geometry:
  Corpo_B_R100, Corpo_B_R106, Corpo_A_R100, Corpo_A_R106 [Alumina_nominal] = imported_body(D:/dev/EMBRAER/P2S13/R08_Divisor_HFSS/c01_juncao\cad\Alumina_nominal.step)
  PTFE_R3_B, PTFE_R2_B, PTFE_R1_B, PTFE_IN_B, PTFE_R3_A, PTFE_R2_A, PTFE_R1_A, PTFE_IN_A [PTFE_terminal] = imported_body(D:/dev/EMBRAER/P2S13/R08_Divisor_HFSS/c01_juncao\cad\PTFE_terminal.step)
  Solda_R3_B, Solda_R2_B, Solda_R1_B, Solda_IN_B, Solda_R3_A, Solda_R2_A, Solda_R1_A, Solda_IN_A [SAC305] = imported_body(D:/dev/EMBRAER/P2S13/R08_Divisor_HFSS/c01_juncao\cad\SAC305.step)
  Substrato [ZYF300] = imported_body(D:/dev/EMBRAER/P2S13/R08_Divisor_HFSS/c01_juncao\cad\ZYF300.step)
  Massa_R3_B, Pino_R3_B, Massa_R2_B, Pino_R2_B, Massa_R1_B, Pino_R1_B, Massa_IN_B, Pino_IN_B, Massa_R3_A, Pino_R3_A, Massa_R2_A, Pino_R2_A, Massa_R1_A, Pino_R1_A, Massa_IN_A, Pino_IN_A [copper] = imported_body(D:/dev/EMBRAER/P2S13/R08_Divisor_HFSS/c01_juncao\cad\copper.step)
  Sinal_B, Sinal_A, Terra [Cobre_vol_Groiss] = imported_body(D:/dev/EMBRAER/P2S13/R08_Divisor_HFSS/c01_juncao\cad\folha_cu.step)
  A_R106_RLC = rectangle(corner=(-37.3mm, 17.8mm, 1.555mm), x_size=0.6mm, y_size=0.4mm)
  A_R100_RLC = rectangle(corner=(-10.111911mm, 8.8mm, 1.555mm), x_size=0.6mm, y_size=0.4mm)
  B_R106_RLC = rectangle(corner=(-37.3mm, -18.2mm, 1.555mm), x_size=0.6mm, y_size=0.4mm)
  B_R100_RLC = rectangle(corner=(-10.111911mm, -9.2mm, 1.555mm), x_size=0.6mm, y_size=0.4mm)
  IN_A_ext = circle(normal=Z, centre=(-56.998567mm, 18mm, -0.18mm), radius=1.515mm)
  IN_A_int = circle(normal=Z, centre=(-56.998567mm, 18mm, -0.18mm), radius=0.45975mm)
  IN_A_ext.subtract(IN_A_int)
  R1_A_ext = circle(normal=Z, centre=(-93.490832mm, 18mm, -0.18mm), radius=1.515mm)
  R1_A_int = circle(normal=Z, centre=(-93.490832mm, 18mm, -0.18mm), radius=0.45975mm)
  R1_A_ext.subtract(R1_A_int)
  R2_A_ext = circle(normal=Z, centre=(2.5091684mm, 18mm, -0.18mm), radius=1.515mm)
  R2_A_int = circle(normal=Z, centre=(2.5091684mm, 18mm, -0.18mm), radius=0.45975mm)
  R2_A_ext.subtract(R2_A_int)
  R3_A_ext = circle(normal=Z, centre=(98.509168mm, 18mm, -0.18mm), radius=1.515mm)
  R3_A_int = circle(normal=Z, centre=(98.509168mm, 18mm, -0.18mm), radius=0.45975mm)
  R3_A_ext.subtract(R3_A_int)
  IN_B_ext = circle(normal=Z, centre=(-56.998567mm, -18mm, -0.18mm), radius=1.515mm)
  IN_B_int = circle(normal=Z, centre=(-56.998567mm, -18mm, -0.18mm), radius=0.45975mm)
  IN_B_ext.subtract(IN_B_int)
  R1_B_ext = circle(normal=Z, centre=(-93.490832mm, -18mm, -0.18mm), radius=1.515mm)
  R1_B_int = circle(normal=Z, centre=(-93.490832mm, -18mm, -0.18mm), radius=0.45975mm)
  R1_B_ext.subtract(R1_B_int)
  R2_B_ext = circle(normal=Z, centre=(2.5091684mm, -18mm, -0.18mm), radius=1.515mm)
  R2_B_int = circle(normal=Z, centre=(2.5091684mm, -18mm, -0.18mm), radius=0.45975mm)
  R2_B_ext.subtract(R2_B_int)
  R3_B_ext = circle(normal=Z, centre=(98.509168mm, -18mm, -0.18mm), radius=1.515mm)
  R3_B_int = circle(normal=Z, centre=(98.509168mm, -18mm, -0.18mm), radius=0.45975mm)
  R3_B_ext.subtract(R3_B_int)
  RadiatingSurface [vacuum] = region(absolute_offset=19.34236mm on all sides)
boundaries and excitations:
  ENIG_faces_expostas: Layered Impedance Faces=Sinal_A.face(at (-42.2671, 12.988, 1.5375), at (-38.8964, 11.1998, 1.5375), at (-50.37, 15.5741, 1.5375), at (2.50917, 16.2422, 1.555), at (-37, 11.7409, 1.5375), at (-56.9986, 16.4621, 1.5375), at (-32.406, 11.484, 1.5375), at (-57.041, 17.3528, 1.5375), at (-27.8119, 11.7751, 1.5375), at (-57.1251, 17.3639, 1.5375), at (-24.7788, 12.0663, 1.5375), at (-57.2071, 17.3858, 1.5375)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) Sinal_B.face(at (-94.7827, -18, 1.5375), at (-95.4245, -22.5505, 1.5375), at (-94.1381, -17.9576, 1.5375), at (2.50917, -16.2422, 1.555), at (-93.8582, -28.6673, 1.5375), at (-94.127, -17.8735, 1.5375), at (-53.5138, -30.2337, 1.5375), at (-94.105, -17.7915, 1.5375), at (-13.1694, -28.6673, 1.5375), at (-94.0726, -17.7131, 1.5375), at (-11.6031, -24.5505, 1.5375), at (-94.0301, -17.6397, 1.5375)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) Terra.face(at (-110, 0, -0.0175), at (0, -32, -0.0175), at (0, 32, -0.0175), at (0, 0, -0.035), at (110, 0, -0.0175), at (-95.0058, -18, -0.0175), at (-58.5136, -18, -0.0175), at (0.994168, -18, -0.0175), at (96.9942, -18, -0.0175), at (-95.0058, 18, -0.0175), at (-58.5136, 18, -0.0175), at (0.994168, 18, -0.0175)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) Frequency=0GHz Layers{Layer1{Thickness=0.0254um Material=Ouro_vol_nominal} Layer2{Thickness=4.5um Material=NiP_vol_nominal} Layer3{LayerType=1 Thickness=0 Material=Cobre_vol_Groiss}}
  A_R106_RLC: Lumped RLC Objects=A_R106_RLC CurrentLine{(-37, 17.8, 1.555) -> (-37, 18.2, 1.555)} RLC_Type=Parallel Resistance=106.06602ohm
  A_R100_RLC: Lumped RLC Objects=A_R100_RLC CurrentLine{(-9.8119106, 8.8, 1.555) -> (-9.8119106, 9.2, 1.555)} RLC_Type=Parallel Resistance=100ohm
  B_R106_RLC: Lumped RLC Objects=B_R106_RLC CurrentLine{(-37, -18.2, 1.555) -> (-37, -17.8, 1.555)} RLC_Type=Parallel Resistance=106.06602ohm
  B_R100_RLC: Lumped RLC Objects=B_R100_RLC CurrentLine{(-9.8119106, -9.2, 1.555) -> (-9.8119106, -8.8, 1.555)} RLC_Type=Parallel Resistance=100ohm
  Open1: Radiation Objects=RadiatingSurface
  IN_A: Lumped Port Objects=IN_A_ext LumpedPortType=Modal Modes{Mode1{IntLine{(-56.538817, 18, -0.18) -> (-55.483567, 18, -0.18)} CharImp=Zpi RenormImp=50ohm}} Impedance=50ohm
  R1_A: Lumped Port Objects=R1_A_ext LumpedPortType=Modal Modes{Mode1{IntLine{(-93.031082, 18, -0.18) -> (-91.975832, 18, -0.18)} CharImp=Zpi RenormImp=50ohm}} Impedance=50ohm
  R2_A: Lumped Port Objects=R2_A_ext LumpedPortType=Modal Modes{Mode1{IntLine{(2.9689184, 18, -0.18) -> (4.0241684, 18, -0.18)} CharImp=Zpi RenormImp=50ohm}} Impedance=50ohm
  R3_A: Lumped Port Objects=R3_A_ext LumpedPortType=Modal Modes{Mode1{IntLine{(98.968918, 18, -0.18) -> (100.02417, 18, -0.18)} CharImp=Zpi RenormImp=50ohm}} Impedance=50ohm
  IN_B: Lumped Port Objects=IN_B_ext LumpedPortType=Modal Modes{Mode1{IntLine{(-56.538817, -18, -0.18) -> (-55.483567, -18, -0.18)} CharImp=Zpi RenormImp=50ohm}} Impedance=50ohm
  R1_B: Lumped Port Objects=R1_B_ext LumpedPortType=Modal Modes{Mode1{IntLine{(-93.031082, -18, -0.18) -> (-91.975832, -18, -0.18)} CharImp=Zpi RenormImp=50ohm}} Impedance=50ohm
  R2_B: Lumped Port Objects=R2_B_ext LumpedPortType=Modal Modes{Mode1{IntLine{(2.9689184, -18, -0.18) -> (4.0241684, -18, -0.18)} CharImp=Zpi RenormImp=50ohm}} Impedance=50ohm
  R3_B: Lumped Port Objects=R3_B_ext LumpedPortType=Modal Modes{Mode1{IntLine{(98.968918, -18, -0.18) -> (100.02417, -18, -0.18)} CharImp=Zpi RenormImp=50ohm}} Impedance=50ohm
mesh:
  initial mesh: MeshMethod=AnsoftClassic
setups:
  Centro: HfssDriven Frequency=5.17GHz MaxDeltaS=0.05 MaximumPasses=6 MinimumPasses=2 MinimumConvergedPasses=2 PercentRefinement=30 BasisOrder=1 DoLambdaRefine=false PortAccuracy=2 DrivenSolverType="Iterative Solver" IterativeResidual=1e-05 DDMSolverResidual=1e-05 SaveRadFieldsOnly
source amplitudes:
  IN_A:1, IN_B:1: 0.5W 0deg
  R1_A:1, R2_A:1, R3_A:1, R1_B:1, R2_B:1, R3_B:1: 0W 0deg
radiation setups:
  3D: Infinite Sphere Theta=0deg..180deg step 2deg Phi=-180deg..180deg step 2deg
  Elevation: Infinite Sphere Theta=-180deg..180deg step 1deg Phi=0deg..90deg step 90deg
  Azimuth: Infinite Sphere Theta=90deg..90deg step 0deg Phi=-180deg..180deg step 1deg
