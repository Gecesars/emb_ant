# Ansys Electronics Desktop project, version 2024.2

design Duplo1x3_Carregado (Circuit)
options: SParamCircuitDef IntegrationMethod=FFT
components:
  S1 = Wilkinson_ajustado_1x3()
  S2 = Wilkinson_ajustado_1x3()
  S3 = antena()
  port IN_A rz=50ohm iz=0ohm EnableNoise=false noisetemp=16.85cel
  port IN_B rz=50ohm iz=0ohm EnableNoise=false noisetemp=16.85cel
nets:
  IN_A: S1.0
  IN_B: S2.0
  R1_A: S3.0, S1.1
  R1_B: S3.1, S2.1
  R2_A: S3.2, S1.2
  R2_B: S3.3, S2.2
  R3_A: S3.4, S1.3
  R3_B: S3.5, S2.3
setups:
  Centro: LinearFrequencyData(false, 0.1, false, "", false) SweepDefinition{Variable=Freq Data=5.17GHz}
