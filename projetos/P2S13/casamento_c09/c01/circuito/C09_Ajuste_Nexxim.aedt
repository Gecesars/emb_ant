# Ansys Electronics Desktop project, version 2024.2

design C09_Confirmacao_HFSS (Circuit)
options: SParamCircuitDef IntegrationMethod=FFT
components:
  S1 = divisor()
  S2 = antena()
  S3 = coaxial()
  S4 = coaxial()
  S5 = coaxial()
  S6 = coaxial()
  S7 = coaxial()
  S8 = coaxial()
  port IN_A rz=50ohm iz=0ohm EnableNoise=false noisetemp=16.85cel
  port IN_B rz=50ohm iz=0ohm EnableNoise=false noisetemp=16.85cel
nets:
  ANT_R1_A: S2.0, S3.1
  ANT_R1_B: S2.1, S4.1
  ANT_R2_A: S2.2, S5.1
  ANT_R2_B: S2.3, S6.1
  ANT_R3_A: S2.4, S7.1
  ANT_R3_B: S2.5, S8.1
  DIV_R1_A: S1.2, S3.0
  DIV_R1_B: S1.3, S4.0
  DIV_R2_A: S1.4, S5.0
  DIV_R2_B: S1.5, S6.0
  DIV_R3_A: S1.6, S7.0
  DIV_R3_B: S1.7, S8.0
  IN_A: S1.0
  IN_B: S1.1
setups:
  Centro: LinearFrequencyData(false, 0.1, false, "", false) SweepDefinition{Variable=Freq Data=5.17GHz}
