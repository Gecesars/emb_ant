# Ansys Electronics Desktop project, version 2024.2

design S8_HFSS_S6_Antena (Circuit)
options: SParamCircuitDef IntegrationMethod=FFT
components:
  S1 = divisor()
  S2 = antena()
  port IN_A rz=50ohm iz=0ohm EnableNoise=false noisetemp=16.85cel
  port IN_B rz=50ohm iz=0ohm EnableNoise=false noisetemp=16.85cel
nets:
  IN_A: S1.0
  IN_B: S1.1
  R1_A: S1.2, S2.0
  R1_B: S1.3, S2.1
  R2_A: S1.4, S2.2
  R2_B: S1.5, S2.3
  R3_A: S1.6, S2.4
  R3_B: S1.7, S2.5
setups:
  Centro: LinearFrequencyData(false, 0.1, false, "", false) SweepDefinition{Variable=Freq Data=5.17GHz}
