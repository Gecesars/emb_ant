# Ansys Electronics Desktop project, version 2024.2
materials:
  vacuum: permittivity=1
  Alumina_nominal: permittivity=9.8 dielectric_loss_tangent=0.0001
  ZYF300: permittivity=2.94 dielectric_loss_tangent=0.0016
  PTFE_terminal: permittivity=2.0363635 dielectric_loss_tangent=0.00027683055
  SAC305: conductivity=7575758
  copper: permeability=0.999991 conductivity=58000000
  NiP_vol_nominal: permeability=1 conductivity=1500000
  Ouro_vol_nominal: permeability=1 conductivity=41000000
  Cobre_vol_Groiss: permeability=1 conductivity=28688604
  PVC_referencia_preliminar: permittivity=2.68 dielectric_loss_tangent=0.008

design Duplo1x3_Planar (HFSS, HFSS Hybrid Modal Network, model units mm)
geometry:
  PTFE_R3_B, PTFE_R2_B, PTFE_R1_B, PTFE_IN_B, PTFE_R3_A, PTFE_R2_A, PTFE_R1_A, PTFE_IN_A [PTFE_terminal] = imported_body(D:/dev/EMBRAER/P2S13/R16_Tubo_PVC/dn100_c02/divisor\cad\PTFE_terminal.step)
  Solda_R3_B, Solda_R2_B, Solda_R1_B, Solda_IN_B, Solda_R3_A, Solda_R2_A, Solda_R1_A, Solda_IN_A [SAC305] = imported_body(D:/dev/EMBRAER/P2S13/R16_Tubo_PVC/dn100_c02/divisor\cad\SAC305.step)
  Substrato [ZYF300] = imported_body(D:/dev/EMBRAER/P2S13/R16_Tubo_PVC/dn100_c02/divisor\cad\ZYF300.step)
  Massa_R3_B, Barril_R3_B, Pino_R3_B, Massa_R2_B, Barril_R2_B, Pino_R2_B, Massa_R1_B, Barril_R1_B, Pino_R1_B, Massa_IN_B, Barril_IN_B, Pino_IN_B, Massa_R3_A, Barril_R3_A, Pino_R3_A, Massa_R2_A, Barril_R2_A, Pino_R2_A, Massa_R1_A, Barril_R1_A, Pino_R1_A, Massa_IN_A, Barril_IN_A, Pino_IN_A [copper] = imported_body(D:/dev/EMBRAER/P2S13/R16_Tubo_PVC/dn100_c02/divisor\cad\copper.step)
  Sinal_B, Sinal_A, Terra, Ilha_inferior_R3_B, Ilha_inferior_R2_B, Ilha_inferior_R1_B, Ilha_inferior_IN_B, Ilha_inferior_R3_A, Ilha_inferior_R2_A, Ilha_inferior_R1_A, Ilha_inferior_IN_A [Cobre_vol_Groiss] = imported_body(D:/dev/EMBRAER/P2S13/R16_Tubo_PVC/dn100_c02/divisor\cad\folha_cu.step)
  IN_A_ext = circle(normal=Z, centre=(2.5091684mm, 19.1mm, -0.18mm), radius=1.515mm)
  IN_A_int = circle(normal=Z, centre=(2.5091684mm, 19.1mm, -0.18mm), radius=0.45975mm)
  IN_A_ext.subtract(IN_A_int)
  R1_A_ext = circle(normal=Z, centre=(-7.1527849mm, 35.834994mm, -0.18mm), radius=1.515mm)
  R1_A_int = circle(normal=Z, centre=(-7.1527849mm, 35.834994mm, -0.18mm), radius=0.45975mm)
  R1_A_ext.subtract(R1_A_int)
  R2_A_ext = circle(normal=Z, centre=(-7.1527849mm, 2.3650059mm, -0.18mm), radius=1.515mm)
  R2_A_int = circle(normal=Z, centre=(-7.1527849mm, 2.3650059mm, -0.18mm), radius=0.45975mm)
  R2_A_ext.subtract(R2_A_int)
  R3_A_ext = circle(normal=Z, centre=(21.833075mm, 19.1mm, -0.18mm), radius=1.515mm)
  R3_A_int = circle(normal=Z, centre=(21.833075mm, 19.1mm, -0.18mm), radius=0.45975mm)
  R3_A_ext.subtract(R3_A_int)
  IN_B_ext = circle(normal=Z, centre=(2.5091684mm, -19.1mm, -0.18mm), radius=1.515mm)
  IN_B_int = circle(normal=Z, centre=(2.5091684mm, -19.1mm, -0.18mm), radius=0.45975mm)
  IN_B_ext.subtract(IN_B_int)
  R1_B_ext = circle(normal=Z, centre=(-7.1527849mm, -35.834994mm, -0.18mm), radius=1.515mm)
  R1_B_int = circle(normal=Z, centre=(-7.1527849mm, -35.834994mm, -0.18mm), radius=0.45975mm)
  R1_B_ext.subtract(R1_B_int)
  R2_B_ext = circle(normal=Z, centre=(-7.1527849mm, -2.3650059mm, -0.18mm), radius=1.515mm)
  R2_B_int = circle(normal=Z, centre=(-7.1527849mm, -2.3650059mm, -0.18mm), radius=0.45975mm)
  R2_B_ext.subtract(R2_B_int)
  R3_B_ext = circle(normal=Z, centre=(21.833075mm, -19.1mm, -0.18mm), radius=1.515mm)
  R3_B_int = circle(normal=Z, centre=(21.833075mm, -19.1mm, -0.18mm), radius=0.45975mm)
  R3_B_ext.subtract(R3_B_int)
  RadiatingSurface [vacuum] = region(absolute_offset=19.34236mm on all sides)
  Tubo_PVC [PVC_referencia_preliminar] = cylinder(axis=X, base_centre=(-175mm, 0mm, -25.09mm), radius=50.8mm, height=350mm)
  Vazio_Tubo = cylinder(axis=X, base_centre=(-175mm, 0mm, -25.09mm), radius=49mm, height=350mm)
  Tubo_PVC.subtract(Vazio_Tubo)
boundaries and excitations:
  ENIG_faces_expostas: Layered Impedance Faces=Ilha_inferior_IN_A.face(at (1.60917, 19.1, -0.0175), at (2.50917, 19.1, -0.035)) Ilha_inferior_IN_B.face(at (1.60917, -19.1, -0.0175), at (2.50917, -19.1, -0.035)) Ilha_inferior_R1_A.face(at (-8.05278, 35.835, -0.0175), at (-7.15278, 35.835, -0.035)) Ilha_inferior_R1_B.face(at (-8.05278, -35.835, -0.0175), at (-7.15278, -35.835, -0.035)) Ilha_inferior_R2_A.face(at (-8.05278, 2.36501, -0.0175), at (-7.15278, 2.36501, -0.035)) Ilha_inferior_R2_B.face(at (-8.05278, -2.36501, -0.0175), at (-7.15278, -2.36501, -0.035)) Ilha_inferior_R3_A.face(at (20.9331, 19.1, -0.0175), at (21.8331, 19.1, -0.035)) Ilha_inferior_R3_B.face(at (20.9331, -19.1, -0.0175), at (21.8331, -19.1, -0.035)) Sinal_A.face(at (17.6082, 19.787, 1.5375), at (13.9647, 19.5835, 1.5375), at (8.66461, 19.3801, 1.5375), at (2.95917, 19.8794, 1.5375), at (-0.325994, 24.5708, 1.5375), at (-2.79987, 29.2626, 1.5375), at (-4.44541, 32.5196, 1.5375), at (-7.60278, 36.6144, 1.5375), at (-5.63526, 31.8326, 1.5375), at (-3.63736, 28.7791, 1.5375), at (-0.811107, 24.2907, 1.5375), at (1.60917, 19.1, 1.5375)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) Sinal_B.face(at (17.6082, -18.413, 1.5375), at (13.9647, -18.6165, 1.5375), at (8.66461, -18.8199, 1.5375), at (2.95917, -18.3206, 1.5375), at (-0.325994, -13.6292, 1.5375), at (-2.79987, -8.93743, 1.5375), at (-4.44541, -5.68039, 1.5375), at (-5.63526, -6.36735, 1.5375), at (-7.60278, -1.58558, 1.5375), at (-3.63736, -9.42095, 1.5375), at (-0.811107, -13.9093, 1.5375), at (1.60917, -19.1, 1.5375)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) Terra.face(at (-10.3599, 0, -0.0175), at (7.34015, -38.7, -0.0175), at (7.34015, 38.7, -0.0175), at (7.34015, 0, -0.035), at (25.0401, 0, -0.0175), at (-8.66778, -35.835, -0.0175), at (0.994168, -19.1, -0.0175), at (-8.66778, -2.36501, -0.0175), at (20.3181, -19.1, -0.0175), at (-8.66778, 2.36501, -0.0175), at (-8.66778, 35.835, -0.0175), at (0.994168, 19.1, -0.0175)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) Frequency=0GHz Layers{Layer1{Thickness=0.0254um Material=Ouro_vol_nominal} Layer2{Thickness=4.5um Material=NiP_vol_nominal} Layer3{LayerType=1 Thickness=0 Material=Cobre_vol_Groiss}}
  Open1: Radiation Objects=RadiatingSurface
  IN_A: Lumped Port Objects=IN_A_ext LumpedPortType=Modal Modes{Mode1{IntLine{(2.9689184, 19.1, -0.18) -> (4.0241684, 19.1, -0.18)} CharImp=Zpi RenormImp=50ohm}} Impedance=50ohm
  R1_A: Lumped Port Objects=R1_A_ext LumpedPortType=Modal Modes{Mode1{IntLine{(-6.6930349, 35.834994, -0.18) -> (-5.6377849, 35.834994, -0.18)} CharImp=Zpi RenormImp=50ohm}} Impedance=50ohm
  R2_A: Lumped Port Objects=R2_A_ext LumpedPortType=Modal Modes{Mode1{IntLine{(-6.6930349, 2.3650059, -0.18) -> (-5.6377849, 2.3650059, -0.18)} CharImp=Zpi RenormImp=50ohm}} Impedance=50ohm
  R3_A: Lumped Port Objects=R3_A_ext LumpedPortType=Modal Modes{Mode1{IntLine{(22.292825, 19.1, -0.18) -> (23.348075, 19.1, -0.18)} CharImp=Zpi RenormImp=50ohm}} Impedance=50ohm
  IN_B: Lumped Port Objects=IN_B_ext LumpedPortType=Modal Modes{Mode1{IntLine{(2.9689184, -19.1, -0.18) -> (4.0241684, -19.1, -0.18)} CharImp=Zpi RenormImp=50ohm}} Impedance=50ohm
  R1_B: Lumped Port Objects=R1_B_ext LumpedPortType=Modal Modes{Mode1{IntLine{(-6.6930349, -35.834994, -0.18) -> (-5.6377849, -35.834994, -0.18)} CharImp=Zpi RenormImp=50ohm}} Impedance=50ohm
  R2_B: Lumped Port Objects=R2_B_ext LumpedPortType=Modal Modes{Mode1{IntLine{(-6.6930349, -2.3650059, -0.18) -> (-5.6377849, -2.3650059, -0.18)} CharImp=Zpi RenormImp=50ohm}} Impedance=50ohm
  R3_B: Lumped Port Objects=R3_B_ext LumpedPortType=Modal Modes{Mode1{IntLine{(22.292825, -19.1, -0.18) -> (23.348075, -19.1, -0.18)} CharImp=Zpi RenormImp=50ohm}} Impedance=50ohm
mesh:
  initial mesh: GlobalCurvilinear{Apply} MeshMethod=AnsoftClassic
setups:
  Centro: HfssDriven Frequency=5.17GHz MaxDeltaS=0.05 MaximumPasses=6 MinimumPasses=2 MinimumConvergedPasses=2 PercentRefinement=60 BasisOrder=1 DoLambdaRefine=false PortAccuracy=2 DrivenSolverType="Direct Solver" SaveRadFieldsOnly
source amplitudes:
  IN_A:1, IN_B:1: 0.5W 0deg
  R1_A:1, R2_A:1, R3_A:1, R1_B:1, R2_B:1, R3_B:1: 0W 0deg
radiation setups:
  3D: Infinite Sphere Theta=0deg..180deg step 2deg Phi=-180deg..180deg step 2deg
  Elevation: Infinite Sphere Theta=-180deg..180deg step 1deg Phi=0deg..90deg step 90deg
  Azimuth: Infinite Sphere Theta=90deg..90deg step 0deg Phi=-180deg..180deg step 1deg
