# Ansys Electronics Desktop project, version 2024.2
materials:
  vacuum: permittivity=1
  POM_nom: permittivity=3.4 dielectric_loss_tangent=0.01
  PTFE_terminal: permittivity=2.0363635 dielectric_loss_tangent=0.00027683055
  ZYF300: permittivity=2.94 dielectric_loss_tangent=0.0016
  RO4350B_R01: permittivity=3.66 dielectric_loss_tangent=0.0037
  AL5052: conductivity=20000000
  SAC305: conductivity=7575758
  copper: permeability=0.999991 conductivity=58000000
  NiP_vol_nominal: permeability=1 conductivity=1500000
  Ouro_vol_nominal: permeability=1 conductivity=41000000
  Cobre_vol_Groiss: permeability=1 conductivity=28688604

design Duas_placas (HFSS, HFSS Hybrid Modal Network, model units mm)
geometry:
  R2_PTFE_B, R2_PTFE_A, R1_PTFE_B, R1_PTFE_A [PTFE_terminal] = imported_body(D:/dev/EMBRAER/P2S13/R00_Refletor_Dobrado/v01_b20_a60\cad\PTFE_terminal.step)
  R2_PCB_RO4350B, R1_PCB_RO4350B [RO4350B_R01] = imported_body(D:/dev/EMBRAER/P2S13/R00_Refletor_Dobrado/v01_b20_a60\cad\RO4350B_R01.step)
  R2_Solda_B, R2_Solda_A, R1_Solda_B, R1_Solda_A [SAC305] = imported_body(D:/dev/EMBRAER/P2S13/R00_Refletor_Dobrado/v01_b20_a60\cad\SAC305.step)
  R2_PTH_B, R2_Blindagem_B, R2_Vivo_B, R2_PTH_A, R2_Blindagem_A, R2_Vivo_A, R2_Via_7, R2_Via_6, R2_Via_5, R2_Via_4, R2_Via_3, R2_Via_2, R2_Via_1, R2_Via_0, R1_PTH_B, R1_Blindagem_B, R1_Vivo_B, R1_PTH_A, R1_Blindagem_A, R1_Vivo_A, R1_Via_7, R1_Via_6, R1_Via_5, R1_Via_4, R1_Via_3, R1_Via_2, R1_Via_1, R1_Via_0 [copper] = imported_body(D:/dev/EMBRAER/P2S13/R00_Refletor_Dobrado/v01_b20_a60\cad\copper.step)
  R2_F_SIG_B_Cu4, R2_F_SIG_B_Cu3, R2_F_SIG_B_Cu2, R2_F_SIG_B_Cu1, R2_F_SIG_B_Cu0, R2_F_SIG_A_Cu0, R2_B_SIG_B_Cu4, R2_B_SIG_B_Cu3, R2_B_SIG_B_Cu2, R2_B_SIG_B_Cu1, R2_B_SIG_B_Cu0, R2_B_SIG_A_Cu0, R2_B_RET_B_Cu0, R2_B_RET_A_Cu0, R2_B_E4_Q3_Cu0, R2_B_E4_Q2_Cu0, R2_B_E3_Q3_Cu0, R2_B_E3_Q2_Cu0, R2_B_E2_Q3_Cu0, R2_B_E2_Q2_Cu0, R2_B_E1_Q3_Cu0, R2_B_E1_Q2_Cu0, R1_F_SIG_B_Cu4, R1_F_SIG_B_Cu3, R1_F_SIG_B_Cu2, R1_F_SIG_B_Cu1, R1_F_SIG_B_Cu0, R1_F_SIG_A_Cu0, R1_B_SIG_B_Cu4, R1_B_SIG_B_Cu3, R1_B_SIG_B_Cu2, R1_B_SIG_B_Cu1, R1_B_SIG_B_Cu0, R1_B_SIG_A_Cu0, R1_B_RET_B_Cu0, R1_B_RET_A_Cu0, R1_B_E4_Q3_Cu0, R1_B_E4_Q2_Cu0, R1_B_E3_Q3_Cu0, R1_B_E3_Q2_Cu0, R1_B_E2_Q3_Cu0, R1_B_E2_Q2_Cu0, R1_B_E1_Q3_Cu0, R1_B_E1_Q2_Cu0 [Cobre_vol_Groiss] = imported_body(D:/dev/EMBRAER/P2S13/R00_Refletor_Dobrado/v01_b20_a60\cad\folha_cu.step)
  R1_A_ext = circle(normal=Z, centre=(-93.490832mm, -32mm, -35.051mm), radius=1.515mm)
  R1_A_int = circle(normal=Z, centre=(-93.490832mm, -32mm, -35.051mm), radius=0.45975mm)
  R1_A_ext.subtract(R1_A_int)
  R1_B_ext = circle(normal=Z, centre=(-93.490832mm, 32mm, -35.051mm), radius=1.515mm)
  R1_B_int = circle(normal=Z, centre=(-93.490832mm, 32mm, -35.051mm), radius=0.45975mm)
  R1_B_ext.subtract(R1_B_int)
  R2_A_ext = circle(normal=Z, centre=(98.509168mm, -32mm, -35.051mm), radius=1.515mm)
  R2_A_int = circle(normal=Z, centre=(98.509168mm, -32mm, -35.051mm), radius=0.45975mm)
  R2_A_ext.subtract(R2_A_int)
  R2_B_ext = circle(normal=Z, centre=(98.509168mm, 32mm, -35.051mm), radius=1.515mm)
  R2_B_int = circle(normal=Z, centre=(98.509168mm, 32mm, -35.051mm), radius=0.45975mm)
  R2_B_ext.subtract(R2_B_int)
  RadiatingSurface [vacuum] = region(absolute_offset=19.646365mm on all sides)
  Refletor_Al2mm [AL5052] = polyline(x=-196mm, yz in mm: (-34.498025, -21.111316) (-23.464102, -2) (-22, -0.53589838) (-20, 0) (20, 0) (22, -0.53589838) (23.464102, -2) (34.498025, -21.111316) (32.765974, -22.111316) (21.732051, -3) (21, -2.2679492) (20, -2) (-20, -2) (-21, -2.2679492) (-21.732051, -3) (-32.765974, -22.111316) (-34.498025, -21.111316), closed, covered, Arc from point 1 over 3, Arc from point 4 over 3, Arc from point 9 over 3, Arc from point 12 over 3)
  Refletor_Al2mm.sweep_along_vector((392mm, 0mm, 0mm))
  Furo_Cabo_0 = cylinder(axis=Z, base_centre=(-93.490832mm, -32mm, -100mm), radius=2.1mm, height=120mm)
  Refletor_Al2mm.subtract(Furo_Cabo_0)
  Furo_Cabo_1 = cylinder(axis=Z, base_centre=(-93.490832mm, 32mm, -100mm), radius=2.1mm, height=120mm)
  Refletor_Al2mm.subtract(Furo_Cabo_1)
  Furo_Cabo_2 = cylinder(axis=Z, base_centre=(98.509168mm, -32mm, -100mm), radius=2.1mm, height=120mm)
  Refletor_Al2mm.subtract(Furo_Cabo_2)
  Furo_Cabo_3 = cylinder(axis=Z, base_centre=(98.509168mm, 32mm, -100mm), radius=2.1mm, height=120mm)
  Refletor_Al2mm.subtract(Furo_Cabo_3)
boundaries and excitations:
  ENIG_faces_expostas: Layered Impedance Faces=R1_B_E1_Q2_Cu0.face(at (-179.079, 2.59297, 14.9315), at (-173.594, 0.267527, 14.9315), at (-181.404, 6.70202, 14.9315), at (-169.351, 1.35121, 14.9315), at (-178.945, 10.9448, 14.9315), at (-168.268, 5.59403, 14.9315), at (-174.702, 13.404, 14.9315), at (-170.593, 11.0786, 14.9315), at (-171.905, 10.6611, 14.9315), at (-170.459, 7.16143, 14.9315), at (-171.783, 3.7834, 14.9315), at (-175.161, 2.45921, 14.9315)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) R1_B_E1_Q3_Cu0.face(at (-174.625, -13.2491, 14.9315), at (-170.563, -10.9506, 14.9315), at (-178.818, -10.8183, 14.9315), at (-168.264, -5.52938, 14.9315), at (-181.249, -6.62457, 14.9315), at (-169.336, -1.3356, 14.9315), at (-178.951, -2.56301, 14.9315), at (-173.529, -0.264435, 14.9315), at (-175.079, -2.43079, 14.9315), at (-171.74, -3.73968, 14.9315), at (-170.431, -7.07867, 14.9315), at (-171.86, -10.5379, 14.9315)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) R1_B_E2_Q2_Cu0.face(at (-131.079, 2.59297, 14.9315), at (-125.594, 0.267527, 14.9315), at (-133.404, 6.70202, 14.9315), at (-121.351, 1.35121, 14.9315), at (-130.945, 10.9448, 14.9315), at (-120.268, 5.59403, 14.9315), at (-126.702, 13.404, 14.9315), at (-122.593, 11.0786, 14.9315), at (-123.905, 10.6611, 14.9315), at (-122.459, 7.16143, 14.9315), at (-123.783, 3.7834, 14.9315), at (-127.161, 2.45921, 14.9315)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) R1_B_E2_Q3_Cu0.face(at (-126.625, -13.2491, 14.9315), at (-122.563, -10.9506, 14.9315), at (-130.818, -10.8183, 14.9315), at (-120.264, -5.52938, 14.9315), at (-133.249, -6.62457, 14.9315), at (-121.336, -1.3356, 14.9315), at (-130.951, -2.56301, 14.9315), at (-125.529, -0.264435, 14.9315), at (-127.079, -2.43079, 14.9315), at (-123.74, -3.73968, 14.9315), at (-122.431, -7.07867, 14.9315), at (-123.86, -10.5379, 14.9315)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) R1_B_E3_Q2_Cu0.face(at (-83.0786, 2.59297, 14.9315), at (-77.594, 0.267527, 14.9315), at (-85.404, 6.70202, 14.9315), at (-73.3512, 1.35121, 14.9315), at (-82.9448, 10.9448, 14.9315), at (-72.2675, 5.59403, 14.9315), at (-78.702, 13.404, 14.9315), at (-74.593, 11.0786, 14.9315), at (-75.905, 10.6611, 14.9315), at (-74.4592, 7.16143, 14.9315), at (-75.7834, 3.7834, 14.9315), at (-79.1614, 2.45921, 14.9315)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) R1_B_E3_Q3_Cu0.face(at (-78.6246, -13.2491, 14.9315), at (-74.563, -10.9506, 14.9315), at (-82.8183, -10.8183, 14.9315), at (-72.2644, -5.52938, 14.9315), at (-85.2491, -6.62457, 14.9315), at (-73.3356, -1.3356, 14.9315), at (-82.9506, -2.56301, 14.9315), at (-77.5294, -0.264435, 14.9315), at (-79.0787, -2.43079, 14.9315), at (-75.7397, -3.73968, 14.9315), at (-74.4308, -7.07867, 14.9315), at (-75.8599, -10.5379, 14.9315)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) R1_B_E4_Q2_Cu0.face(at (-35.0786, 2.59297, 14.9315), at (-29.594, 0.267527, 14.9315), at (-37.404, 6.70202, 14.9315), at (-25.3512, 1.35121, 14.9315), at (-34.9448, 10.9448, 14.9315), at (-24.2675, 5.59403, 14.9315), at (-30.702, 13.404, 14.9315), at (-26.593, 11.0786, 14.9315), at (-27.905, 10.6611, 14.9315), at (-26.4592, 7.16143, 14.9315), at (-27.7834, 3.7834, 14.9315), at (-31.1614, 2.45921, 14.9315)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) R1_B_E4_Q3_Cu0.face(at (-30.6246, -13.2491, 14.9315), at (-26.563, -10.9506, 14.9315), at (-34.8183, -10.8183, 14.9315), at (-24.2644, -5.52938, 14.9315), at (-37.2491, -6.62457, 14.9315), at (-25.3356, -1.3356, 14.9315), at (-34.9506, -2.56301, 14.9315), at (-29.5294, -0.264435, 14.9315), at (-31.0787, -2.43079, 14.9315), at (-27.7397, -3.73968, 14.9315), at (-26.4308, -7.07867, 14.9315), at (-27.8599, -10.5379, 14.9315)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) R1_B_RET_A_Cu0.face(at (-72.0644, -5.52938, 14.9315), at (-72.066, -8.73638, 14.9315), at (-72.2508, -2.13752, 14.9315), at (-72.0675, -8.78696, 14.9315), at (-72.4352, -1.93751, 14.9315), at (-72.2792, -9.04764, 14.9315), at (-72.3974, -1.78111, 14.9315), at (-72.4908, -15.1296, 14.9315), at (-72.3121, -1.49972, 14.9315), at (-60.4908, -21, 14.9315), at (-72.2078, -1.24558, 14.9315), at (-48.4908, -25, 14.9315)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) R1_B_RET_B_Cu0.face(at (-161.427, 0.264435, 14.9315), at (-157.049, 2.56301, 14.9315), at (-163.547, 0.227286, 14.9315), at (-154.751, 6.62457, 14.9315), at (-163.648, 0.145069, 14.9315), at (-157.182, 10.8183, 14.9315), at (-165.316, 0.1, 14.9315), at (-161.052, 13.2491, 14.9315), at (-166.639, 0.383666, 14.9315), at (-162.491, 14.1246, 14.9315), at (-166.844, 1.15577, 14.9315), at (-141.491, 15, 14.9315)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) R1_B_SIG_A_Cu0.face(at (-92.6925, -32.0523, 14.9315), at (-93.486, -32, 14.914), at (-92.6925, -32.0523, 14.9315), at (-92.6908, -32, 14.9315), at (-92.6925, -31.9477, 14.9315), at (-92.7038, -32.1432, 14.9315), at (-92.6925, -31.9477, 14.9315), at (-92.7038, -31.8568, 14.9315), at (-92.7253, -32.2322, 14.9315), at (-92.7253, -32.2322, 14.9315), at (-92.7253, -31.7678, 14.9315), at (-92.7292, -32.2447, 14.9315)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) R1_B_SIG_B_Cu0.face(at (-169.014, -1.01434, 14.9315), at (-167.653, -0.347013, 14.9315), at (-168.347, 0.347013, 14.9315), at (-168, 0, 14.914), at (-166.986, 1.01434, 14.9315), at (-168.947, -0.747412, 14.9315), at (-167.453, 0.747412, 14.9315)) R1_B_SIG_B_Cu1.face(at (-121.014, -1.01434, 14.9315), at (-119.653, -0.347013, 14.9315), at (-120.347, 0.347013, 14.9315), at (-120, 0, 14.914), at (-118.986, 1.01434, 14.9315), at (-120.947, -0.747412, 14.9315), at (-119.453, 0.747412, 14.9315)) R1_B_SIG_B_Cu2.face(at (-73.0143, -1.01434, 14.9315), at (-71.653, -0.347013, 14.9315), at (-72.347, 0.347013, 14.9315), at (-72, 0, 14.914), at (-70.9857, 1.01434, 14.9315), at (-72.9474, -0.747412, 14.9315), at (-71.4526, 0.747412, 14.9315)) R1_B_SIG_B_Cu3.face(at (-24.347, 0.347013, 14.9315), at (-25.0143, -1.01434, 14.9315), at (-22.9857, 1.01434, 14.9315), at (-24, 0, 14.914), at (-23.653, -0.347013, 14.9315), at (-24.9474, -0.747412, 14.9315), at (-23.4526, 0.747412, 14.9315)) R1_B_SIG_B_Cu4.face(at (-92.6925, 31.9477, 14.9315), at (-93.486, 32, 14.914), at (-92.6925, 31.9477, 14.9315), at (-92.6908, 32, 14.9315), at (-92.6925, 32.0523, 14.9315), at (-92.7038, 31.8568, 14.9315), at (-92.6925, 32.0523, 14.9315), at (-92.7038, 32.1432, 14.9315), at (-92.7253, 31.7678, 14.9315), at (-92.7253, 31.7678, 14.9315), at (-92.7253, 32.2322, 14.9315), at (-92.7292, 31.7553, 14.9315)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) R1_F_SIG_A_Cu0.face(at (-80.0206, -30.3543, 15.7265), at (-93.4908, -29.6406, 15.7265), at (-73.7244, -31.068, 15.7265), at (-97.4257, -13.6656, 15.744), at (-106.961, -30.3543, 15.7265), at (-67.4283, -30.284, 15.7265), at (-113.257, -31.068, 15.7265), at (-63.9316, -29.5, 15.7265), at (-119.553, -30.284, 15.7265), at (-60.4348, -30.3441, 15.7265), at (-123.05, -29.5, 15.7265), at (-53.3687, -31.1883, 15.7265)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) R1_F_SIG_B_Cu0.face(at (-168.48, -0.480479, 15.7265), at (-169.602, -0.907572, 15.7265), at (-168.908, -1.6016, 15.7265), at (-171.63, -3.63005, 15.744), at (-170.696, -1.36136, 15.7265), at (-169.361, -2.69602, 15.7265), at (-173.093, -1.04104, 15.7265), at (-169.041, -5.09259, 15.7265), at (-175.169, -1.53179, 15.7265), at (-169.532, -7.16884, 15.7265), at (-173.296, -2.02254, 15.7265), at (-170.023, -5.29587, 15.7265)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) R1_F_SIG_B_Cu1.face(at (-120.48, -0.480479, 15.7265), at (-121.602, -0.907572, 15.7265), at (-120.908, -1.6016, 15.7265), at (-123.63, -3.63005, 15.744), at (-122.696, -1.36136, 15.7265), at (-121.361, -2.69602, 15.7265), at (-125.093, -1.04104, 15.7265), at (-121.041, -5.09259, 15.7265), at (-127.169, -1.53179, 15.7265), at (-121.532, -7.16884, 15.7265), at (-125.296, -2.02254, 15.7265), at (-122.023, -5.29587, 15.7265)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) R1_F_SIG_B_Cu2.face(at (-72.4805, -0.480479, 15.7265), at (-73.6016, -0.907572, 15.7265), at (-72.9076, -1.6016, 15.7265), at (-75.63, -3.63005, 15.744), at (-74.696, -1.36136, 15.7265), at (-73.3614, -2.69602, 15.7265), at (-77.0926, -1.04104, 15.7265), at (-73.041, -5.09259, 15.7265), at (-79.1688, -1.53179, 15.7265), at (-73.5318, -7.16884, 15.7265), at (-77.2959, -2.02254, 15.7265), at (-74.0225, -5.29587, 15.7265)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) R1_F_SIG_B_Cu3.face(at (-24.4805, -0.480479, 15.7265), at (-25.6016, -0.907572, 15.7265), at (-24.9076, -1.6016, 15.7265), at (-27.63, -3.63005, 15.744), at (-26.696, -1.36136, 15.7265), at (-25.3614, -2.69602, 15.7265), at (-29.0926, -1.04104, 15.7265), at (-25.041, -5.09259, 15.7265), at (-31.1688, -1.53179, 15.7265), at (-25.5318, -7.16884, 15.7265), at (-29.2959, -2.02254, 15.7265), at (-26.0225, -5.29587, 15.7265)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) R1_F_SIG_B_Cu4.face(at (-164.679, 2.16216, 15.7265), at (-164.645, 2.66144, 15.7265), at (-165.144, 1.69746, 15.7265), at (-94.2382, 17.2136, 15.744), at (-164.645, 2.73061, 15.7265), at (-166.391, 0.915464, 15.7265), at (-164.679, 9.97674, 15.7265), at (-167.52, 0.480479, 15.7265), at (-157.087, 17.1883, 15.7265), at (-167.085, 1.60949, 15.7265), at (-149.495, 17.379, 15.7265), at (-166.303, 10.6016, 15.7265)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) R2_B_E1_Q2_Cu0.face(at (12.9214, 2.59297, 14.9315), at (18.406, 0.267527, 14.9315), at (10.596, 6.70202, 14.9315), at (22.6488, 1.35121, 14.9315), at (13.0552, 10.9448, 14.9315), at (23.7325, 5.59403, 14.9315), at (17.298, 13.404, 14.9315), at (21.407, 11.0786, 14.9315), at (20.095, 10.6611, 14.9315), at (21.5408, 7.16143, 14.9315), at (20.2166, 3.7834, 14.9315), at (16.8386, 2.45921, 14.9315)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) R2_B_E1_Q3_Cu0.face(at (17.3754, -13.2491, 14.9315), at (21.437, -10.9506, 14.9315), at (13.1817, -10.8183, 14.9315), at (23.7356, -5.52938, 14.9315), at (10.7509, -6.62457, 14.9315), at (22.6644, -1.3356, 14.9315), at (13.0494, -2.56301, 14.9315), at (18.4706, -0.264435, 14.9315), at (16.9213, -2.43079, 14.9315), at (20.2603, -3.73968, 14.9315), at (21.5692, -7.07867, 14.9315), at (20.1401, -10.5379, 14.9315)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) R2_B_E2_Q2_Cu0.face(at (60.9214, 2.59297, 14.9315), at (66.406, 0.267527, 14.9315), at (58.596, 6.70202, 14.9315), at (70.6488, 1.35121, 14.9315), at (61.0552, 10.9448, 14.9315), at (71.7325, 5.59403, 14.9315), at (65.298, 13.404, 14.9315), at (69.407, 11.0786, 14.9315), at (68.095, 10.6611, 14.9315), at (69.5408, 7.16143, 14.9315), at (68.2166, 3.7834, 14.9315), at (64.8386, 2.45921, 14.9315)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) R2_B_E2_Q3_Cu0.face(at (65.3754, -13.2491, 14.9315), at (69.437, -10.9506, 14.9315), at (61.1817, -10.8183, 14.9315), at (71.7356, -5.52938, 14.9315), at (58.7509, -6.62457, 14.9315), at (70.6644, -1.3356, 14.9315), at (61.0494, -2.56301, 14.9315), at (66.4706, -0.264435, 14.9315), at (64.9213, -2.43079, 14.9315), at (68.2603, -3.73968, 14.9315), at (69.5692, -7.07867, 14.9315), at (68.1401, -10.5379, 14.9315)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) R2_B_E3_Q2_Cu0.face(at (108.921, 2.59297, 14.9315), at (114.406, 0.267527, 14.9315), at (106.596, 6.70202, 14.9315), at (118.649, 1.35121, 14.9315), at (109.055, 10.9448, 14.9315), at (119.732, 5.59403, 14.9315), at (113.298, 13.404, 14.9315), at (117.407, 11.0786, 14.9315), at (116.095, 10.6611, 14.9315), at (117.541, 7.16143, 14.9315), at (116.217, 3.7834, 14.9315), at (112.839, 2.45921, 14.9315)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) R2_B_E3_Q3_Cu0.face(at (113.375, -13.2491, 14.9315), at (117.437, -10.9506, 14.9315), at (109.182, -10.8183, 14.9315), at (119.736, -5.52938, 14.9315), at (106.751, -6.62457, 14.9315), at (118.664, -1.3356, 14.9315), at (109.049, -2.56301, 14.9315), at (114.471, -0.264435, 14.9315), at (112.921, -2.43079, 14.9315), at (116.26, -3.73968, 14.9315), at (117.569, -7.07867, 14.9315), at (116.14, -10.5379, 14.9315)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) R2_B_E4_Q2_Cu0.face(at (156.921, 2.59297, 14.9315), at (162.406, 0.267527, 14.9315), at (154.596, 6.70202, 14.9315), at (166.649, 1.35121, 14.9315), at (157.055, 10.9448, 14.9315), at (167.732, 5.59403, 14.9315), at (161.298, 13.404, 14.9315), at (165.407, 11.0786, 14.9315), at (164.095, 10.6611, 14.9315), at (165.541, 7.16143, 14.9315), at (164.217, 3.7834, 14.9315), at (160.839, 2.45921, 14.9315)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) R2_B_E4_Q3_Cu0.face(at (161.375, -13.2491, 14.9315), at (165.437, -10.9506, 14.9315), at (157.182, -10.8183, 14.9315), at (167.736, -5.52938, 14.9315), at (154.751, -6.62457, 14.9315), at (166.664, -1.3356, 14.9315), at (157.049, -2.56301, 14.9315), at (162.471, -0.264435, 14.9315), at (160.921, -2.43079, 14.9315), at (164.26, -3.73968, 14.9315), at (165.569, -7.07867, 14.9315), at (164.14, -10.5379, 14.9315)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) R2_B_RET_A_Cu0.face(at (119.936, -5.52938, 14.9315), at (119.934, -8.73638, 14.9315), at (119.749, -2.13752, 14.9315), at (119.932, -8.78696, 14.9315), at (119.565, -1.93751, 14.9315), at (119.721, -9.04764, 14.9315), at (119.603, -1.78111, 14.9315), at (119.509, -15.1296, 14.9315), at (119.688, -1.49972, 14.9315), at (131.509, -21, 14.9315), at (119.792, -1.24558, 14.9315), at (143.509, -25, 14.9315)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) R2_B_RET_B_Cu0.face(at (30.5732, 0.264435, 14.9315), at (34.9506, 2.56301, 14.9315), at (28.4533, 0.227286, 14.9315), at (37.2491, 6.62457, 14.9315), at (28.3516, 0.145069, 14.9315), at (34.8183, 10.8183, 14.9315), at (26.6838, 0.1, 14.9315), at (30.9484, 13.2491, 14.9315), at (25.3605, 0.383666, 14.9315), at (29.5092, 14.1246, 14.9315), at (25.1558, 1.15577, 14.9315), at (50.5092, 15, 14.9315)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) R2_B_SIG_A_Cu0.face(at (99.3075, -32.0523, 14.9315), at (98.514, -32, 14.914), at (99.3075, -32.0523, 14.9315), at (99.3092, -32, 14.9315), at (99.3075, -31.9477, 14.9315), at (99.2962, -32.1432, 14.9315), at (99.3075, -31.9477, 14.9315), at (99.2962, -31.8568, 14.9315), at (99.2747, -32.2322, 14.9315), at (99.2747, -32.2322, 14.9315), at (99.2747, -31.7678, 14.9315), at (99.2708, -32.2447, 14.9315)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) R2_B_SIG_B_Cu0.face(at (22.9857, -1.01434, 14.9315), at (24.347, -0.347013, 14.9315), at (23.653, 0.347013, 14.9315), at (24, 0, 14.914), at (25.0143, 1.01434, 14.9315), at (23.0526, -0.747412, 14.9315), at (24.5474, 0.747412, 14.9315)) R2_B_SIG_B_Cu1.face(at (70.9857, -1.01434, 14.9315), at (72.347, -0.347013, 14.9315), at (71.653, 0.347013, 14.9315), at (72, 0, 14.914), at (73.0143, 1.01434, 14.9315), at (71.0526, -0.747412, 14.9315), at (72.5474, 0.747412, 14.9315)) R2_B_SIG_B_Cu2.face(at (118.986, -1.01434, 14.9315), at (120.347, -0.347013, 14.9315), at (119.653, 0.347013, 14.9315), at (120, 0, 14.914), at (121.014, 1.01434, 14.9315), at (119.053, -0.747412, 14.9315), at (120.547, 0.747412, 14.9315)) R2_B_SIG_B_Cu3.face(at (167.653, 0.347013, 14.9315), at (166.986, -1.01434, 14.9315), at (169.014, 1.01434, 14.9315), at (168, 0, 14.914), at (168.347, -0.347013, 14.9315), at (167.053, -0.747412, 14.9315), at (168.547, 0.747412, 14.9315)) R2_B_SIG_B_Cu4.face(at (99.3075, 31.9477, 14.9315), at (98.514, 32, 14.914), at (99.3075, 31.9477, 14.9315), at (99.3092, 32, 14.9315), at (99.3075, 32.0523, 14.9315), at (99.2962, 31.8568, 14.9315), at (99.3075, 32.0523, 14.9315), at (99.2962, 32.1432, 14.9315), at (99.2747, 31.7678, 14.9315), at (99.2747, 31.7678, 14.9315), at (99.2747, 32.2322, 14.9315), at (99.2708, 31.7553, 14.9315)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) R2_F_SIG_A_Cu0.face(at (111.979, -30.3543, 15.7265), at (98.5092, -29.6406, 15.7265), at (118.276, -31.068, 15.7265), at (94.5743, -13.6656, 15.744), at (85.0389, -30.3543, 15.7265), at (124.572, -30.284, 15.7265), at (78.7428, -31.068, 15.7265), at (128.068, -29.5, 15.7265), at (72.4466, -30.284, 15.7265), at (131.565, -30.3441, 15.7265), at (68.9499, -29.5, 15.7265), at (138.631, -31.1883, 15.7265)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) R2_F_SIG_B_Cu0.face(at (23.5195, -0.480479, 15.7265), at (22.3984, -0.907572, 15.7265), at (23.0924, -1.6016, 15.7265), at (20.37, -3.63005, 15.744), at (21.304, -1.36136, 15.7265), at (22.6386, -2.69602, 15.7265), at (18.9074, -1.04104, 15.7265), at (22.959, -5.09259, 15.7265), at (16.8312, -1.53179, 15.7265), at (22.4682, -7.16884, 15.7265), at (18.7041, -2.02254, 15.7265), at (21.9775, -5.29587, 15.7265)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)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 Frequency=0GHz Layers{Layer1{Thickness=0.0254um Material=Ouro_vol_nominal} Layer2{Thickness=4.5um Material=NiP_vol_nominal} Layer3{LayerType=1 Thickness=0 Material=Cobre_vol_Groiss}}
  Open1: Radiation Objects=RadiatingSurface
  R1_A: Lumped Port Objects=R1_A_ext LumpedPortType=Modal Modes{Mode1{IntLine{(-93.031082, -32, -35.051) -> (-91.975832, -32, -35.051)} CharImp=Zpi RenormImp=50ohm}} Impedance=50ohm
  R1_B: Lumped Port Objects=R1_B_ext LumpedPortType=Modal Modes{Mode1{IntLine{(-93.031082, 32, -35.051) -> (-91.975832, 32, -35.051)} CharImp=Zpi RenormImp=50ohm}} Impedance=50ohm
  R2_A: Lumped Port Objects=R2_A_ext LumpedPortType=Modal Modes{Mode1{IntLine{(98.968918, -32, -35.051) -> (100.02417, -32, -35.051)} CharImp=Zpi RenormImp=50ohm}} Impedance=50ohm
  R2_B: Lumped Port Objects=R2_B_ext LumpedPortType=Modal Modes{Mode1{IntLine{(98.968918, 32, -35.051) -> (100.02417, 32, -35.051)} CharImp=Zpi RenormImp=50ohm}} Impedance=50ohm
mesh:
  initial mesh: MeshMethod=AnsoftClassic
setups:
  Centro: HfssDriven Frequency=5.17GHz MaxDeltaS=0.05 MaximumPasses=6 MinimumPasses=2 MinimumConvergedPasses=2 PercentRefinement=50 BasisOrder=1 DoLambdaRefine=false PortAccuracy=2 DrivenSolverType="Iterative Solver" IterativeResidual=1e-05 DDMSolverResidual=1e-05 SaveRadFieldsOnly ExpressionCache{CacheItem{Title=P2S13_Campo_00 Expression=dB(RealizedGainTotal) Intrinsics="Phi='90deg' Theta='0deg'" TraceID=61 ReportType=3} CacheItem{Title=P2S13_Campo_01 Expression=dB(RealizedGainTotal) Intrinsics="Phi='90deg' Theta='-50deg'" TraceID=62 ReportType=3} CacheItem{Title=P2S13_Campo_02 Expression=dB(RealizedGainTotal) Intrinsics="Phi='90deg' Theta='50deg'" TraceID=63 ReportType=3} CacheItem{Title=P2S13_Campo_03 Expression=dB(RealizedGainTotal) Intrinsics="Phi='90deg' Theta='-60deg'" TraceID=64 ReportType=3} CacheItem{Title=P2S13_Campo_04 Expression=dB(RealizedGainTotal) Intrinsics="Phi='90deg' Theta='60deg'" TraceID=65 ReportType=3} CacheItem{Title=P2S13_Campo_05 Expression=dB(RealizedGainTotal) Intrinsics="Phi='0deg' Theta='-8deg'" TraceID=66 ReportType=3} CacheItem{Title=P2S13_Campo_06 Expression=dB(RealizedGainTotal) Intrinsics="Phi='0deg' Theta='8deg'" TraceID=67 ReportType=3} CacheItem{Title=P2S13_Campo_07 Expression=dB(RealizedGainTotal) Intrinsics="Phi='0deg' Theta='-10deg'" TraceID=68 ReportType=3} CacheItem{Title=P2S13_Campo_08 Expression=dB(RealizedGainTotal) Intrinsics="Phi='0deg' Theta='10deg'" TraceID=69 ReportType=3}}
source amplitudes:
  R1_A:1, R1_B:1, R2_A:1, R2_B:1: 0.25W 0deg
radiation setups:
  3D: Infinite Sphere Theta=0deg..180deg step 2deg Phi=-180deg..180deg step 2deg
  Elevation: Infinite Sphere Theta=-180deg..180deg step 1deg Phi=0deg..90deg step 90deg
  Azimuth: Infinite Sphere Theta=90deg..90deg step 0deg Phi=-180deg..180deg step 1deg
  HV: Infinite Sphere Theta=-180deg..180deg step 0.25deg Phi=0deg..90deg step 90deg
reports:
  ALL_H: dB(RealizedGainTotal), dB(GainTotal), dB(DirTotal), re(rETheta), im(rETheta), re(rEPhi), im(rEPhi) vs Theta on Centro : LastAdaptive, HV [Phi=90deg Freq=5170MHz]
  ALL_V: dB(RealizedGainTotal), dB(GainTotal), dB(DirTotal), re(rETheta), im(rETheta), re(rEPhi), im(rEPhi) vs Theta on Centro : LastAdaptive, HV [Phi=0deg Freq=5170MHz]
  POL_A_H: dB(RealizedGainTotal), dB(GainTotal), dB(DirTotal), re(rETheta), im(rETheta), re(rEPhi), im(rEPhi) vs Theta on Centro : LastAdaptive, HV [Phi=90deg Freq=5170MHz]
  POL_A_V: dB(RealizedGainTotal), dB(GainTotal), dB(DirTotal), re(rETheta), im(rETheta), re(rEPhi), im(rEPhi) vs Theta on Centro : LastAdaptive, HV [Phi=0deg Freq=5170MHz]
  POL_B_H: dB(RealizedGainTotal), dB(GainTotal), dB(DirTotal), re(rETheta), im(rETheta), re(rEPhi), im(rEPhi) vs Theta on Centro : LastAdaptive, HV [Phi=90deg Freq=5170MHz]
  POL_B_V: dB(RealizedGainTotal), dB(GainTotal), dB(DirTotal), re(rETheta), im(rETheta), re(rEPhi), im(rEPhi) vs Theta on Centro : LastAdaptive, HV [Phi=0deg Freq=5170MHz]
  R1_A_H: dB(RealizedGainTotal), dB(GainTotal), dB(DirTotal), re(rETheta), im(rETheta), re(rEPhi), im(rEPhi) vs Theta on Centro : LastAdaptive, HV [Phi=90deg Freq=5170MHz]
  R1_A_V: dB(RealizedGainTotal), dB(GainTotal), dB(DirTotal), re(rETheta), im(rETheta), re(rEPhi), im(rEPhi) vs Theta on Centro : LastAdaptive, HV [Phi=0deg Freq=5170MHz]
  R1_B_H: dB(RealizedGainTotal), dB(GainTotal), dB(DirTotal), re(rETheta), im(rETheta), re(rEPhi), im(rEPhi) vs Theta on Centro : LastAdaptive, HV [Phi=90deg Freq=5170MHz]
  R1_B_V: dB(RealizedGainTotal), dB(GainTotal), dB(DirTotal), re(rETheta), im(rETheta), re(rEPhi), im(rEPhi) vs Theta on Centro : LastAdaptive, HV [Phi=0deg Freq=5170MHz]
  R2_A_H: dB(RealizedGainTotal), dB(GainTotal), dB(DirTotal), re(rETheta), im(rETheta), re(rEPhi), im(rEPhi) vs Theta on Centro : LastAdaptive, HV [Phi=90deg Freq=5170MHz]
  R2_A_V: dB(RealizedGainTotal), dB(GainTotal), dB(DirTotal), re(rETheta), im(rETheta), re(rEPhi), im(rEPhi) vs Theta on Centro : LastAdaptive, HV [Phi=0deg Freq=5170MHz]
  R2_B_H: dB(RealizedGainTotal), dB(GainTotal), dB(DirTotal), re(rETheta), im(rETheta), re(rEPhi), im(rEPhi) vs Theta on Centro : LastAdaptive, HV [Phi=90deg Freq=5170MHz]
  R2_B_V: dB(RealizedGainTotal), dB(GainTotal), dB(DirTotal), re(rETheta), im(rETheta), re(rEPhi), im(rEPhi) vs Theta on Centro : LastAdaptive, HV [Phi=0deg Freq=5170MHz]
