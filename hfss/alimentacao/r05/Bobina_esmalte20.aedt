# Ansys Electronics Desktop project, version 2024.2
materials:
  vacuum: permittivity=1
  PTFE_cabo: permittivity=2.0363635 dielectric_loss_tangent=0.00027683055
  Esmalte_hipotese: permittivity=4.5 dielectric_loss_tangent=0.03
  copper: permeability=0.999991 conductivity=58000000

design Bobina_esmalte20 (HFSS, HFSS Hybrid Modal Network, model units mm)
geometry:
  copper [copper] = imported_body(D:/dev/EMBRAER/P1H/R05_Correcao\cupons\Bobina_esmalte20\copper.step)
  PTFE [PTFE_cabo] = imported_body(D:/dev/EMBRAER/P1H/R05_Correcao\cupons\Bobina_esmalte20\PTFE.step)
  Esmalte_hipotese [Esmalte_hipotese] = imported_body(D:/dev/EMBRAER/P1H/R05_Correcao\cupons\Bobina_esmalte20\Esmalte_hipotese.step)
  Secao_Entrada = circle(normal=Z, centre=(2.5091684mm, -19.25mm, -15.52mm), radius=1.515mm)
  Interior_Entrada = circle(normal=Z, centre=(2.5091684mm, -19.25mm, -15.52mm), radius=0.45975mm)
  Secao_Entrada.subtract(Interior_Entrada)
  Secao_Saida = circle(normal=Z, centre=(2.5091684mm, -19.25mm, -3.52mm), radius=1.515mm)
  Interior_Saida = circle(normal=Z, centre=(2.5091684mm, -19.25mm, -3.52mm), radius=0.45975mm)
  Secao_Saida.subtract(Interior_Saida)
  RadiatingSurface [vacuum] = region(absolute_offset=19.646365mm on all sides)
boundaries and excitations:
  Open1: Radiation Objects=RadiatingSurface
  Entrada: Lumped Port Objects=Secao_Entrada LumpedPortType=Modal Modes{Mode1{IntLine{(2.9689184, -19.25, -15.52) -> (4.0241684, -19.25, -15.52)} CharImp=Zpi RenormImp=50ohm}} Impedance=50ohm
  Saida: Lumped Port Objects=Secao_Saida LumpedPortType=Modal Modes{Mode1{IntLine{(2.9689184, -19.25, -3.52) -> (4.0241684, -19.25, -3.52)} CharImp=Zpi RenormImp=50ohm}} Impedance=50ohm
setups:
  Cupom: HfssDriven Frequency=5.17GHz MaxDeltaS=0.008 MaximumPasses=14 MinimumPasses=3 MinimumConvergedPasses=2 PercentRefinement=24 BasisOrder=-1 PortAccuracy=2 DrivenSolverType="Direct Solver"
    sweep Banda: 5090MHz to 5250MHz step 10MHz; Type=Discrete
source amplitudes:
  Entrada:1: 1W 0deg
  Saida:1: 0W 0deg
radiation setups:
  3D: Infinite Sphere Theta=0deg..180deg step 2deg Phi=-180deg..180deg step 2deg
  Elevation: Infinite Sphere Theta=-180deg..180deg step 1deg Phi=0deg..90deg step 90deg
  Azimuth: Infinite Sphere Theta=90deg..90deg step 0deg Phi=-180deg..180deg step 1deg
