# Ansys Electronics Desktop project, version 2024.2
materials:
  vacuum: permittivity=1
  ZYF300: permittivity=2.94 dielectric_loss_tangent=0.0016
  PTFE_terminal: permittivity=2.0363635 dielectric_loss_tangent=0.00027683055
  SAC305: conductivity=7575758
  copper: permeability=0.999991 conductivity=58000000
  NiP_vol_nominal: permeability=1 conductivity=1500000
  Ouro_vol_nominal: permeability=1 conductivity=41000000
  Cobre_vol_Groiss: permeability=1 conductivity=28688604

design Divisor_completo (HFSS, HFSS Hybrid Modal Network, model units mm)
geometry:
  Isol_terminal_B5, Isol_terminal_B4, Isol_terminal_B3, Isol_terminal_B2, Isol_terminal_B1, Isol_terminal_B_IN, Isol_terminal_A5, Isol_terminal_A4, Isol_terminal_A3, Isol_terminal_A2, Isol_terminal_A1, Isol_terminal_A_IN [PTFE_terminal] = imported_body(D:/dev/EMBRAER/P1H/R06_sem_cabos\divisor_superior\cad\PTFE_terminal.step)
  Solda_Superior_B5, Solda_Superior_B4, Solda_Superior_B3, Solda_Superior_B2, Solda_Superior_B1, Solda_Superior_B_IN, Solda_Superior_A5, Solda_Superior_A4, Solda_Superior_A3, Solda_Superior_A2, Solda_Superior_A1, Solda_Superior_A_IN [SAC305] = imported_body(D:/dev/EMBRAER/P1H/R06_sem_cabos\divisor_superior\cad\SAC305.step)
  ZYF300 [ZYF300] = imported_body(D:/dev/EMBRAER/P1H/R06_sem_cabos\divisor_superior\cad\ZYF300.step)
  Massa_terminal_B5, Terminal_B5, Massa_terminal_B4, Terminal_B4, Massa_terminal_B3, Terminal_B3, Massa_terminal_B2, Terminal_B2, Massa_terminal_B1, Terminal_B1, Massa_terminal_B_IN, Terminal_B_IN, Massa_terminal_A5, Terminal_A5, Massa_terminal_A4, Terminal_A4, Massa_terminal_A3, Terminal_A3, Massa_terminal_A2, Terminal_A2, Massa_terminal_A1, Terminal_A1, Massa_terminal_A_IN, Terminal_A_IN [copper] = imported_body(D:/dev/EMBRAER/P1H/R06_sem_cabos\divisor_superior\cad\copper.step)
  Estrela_Superior_B, Estrela_Superior_A, Massa_Superior, Pad_Superior_B5, Pad_Superior_B4, Pad_Superior_B3, Pad_Superior_B2, Pad_Superior_B1, Pad_Superior_B_IN, Pad_Superior_A5, Pad_Superior_A4, Pad_Superior_A3, Pad_Superior_A2, Pad_Superior_A1, Pad_Superior_A_IN [Cobre_vol_Groiss] = imported_body(D:/dev/EMBRAER/P1H/R06_sem_cabos\divisor_superior\cad\folha_cu.step)
  A_IN_ext = circle(normal=Z, centre=(134.00917mm, -19.25mm, -11.7mm), radius=1.515mm)
  A_IN_int = circle(normal=Z, centre=(134.00917mm, -19.25mm, -11.7mm), radius=0.525mm)
  A_IN_ext.subtract(A_IN_int)
  A1_ext = circle(normal=Z, centre=(119.55311mm, -23.947058mm, -11.7mm), radius=1.515mm)
  A1_int = circle(normal=Z, centre=(119.55311mm, -23.947058mm, -11.7mm), radius=0.525mm)
  A1_ext.subtract(A1_int)
  A2_ext = circle(normal=Z, centre=(125.07483mm, -6.9529417mm, -11.7mm), radius=1.515mm)
  A2_int = circle(normal=Z, centre=(125.07483mm, -6.9529417mm, -11.7mm), radius=0.525mm)
  A2_ext.subtract(A2_int)
  A3_ext = circle(normal=Z, centre=(134.00917mm, -34.45mm, -11.7mm), radius=1.515mm)
  A3_int = circle(normal=Z, centre=(134.00917mm, -34.45mm, -11.7mm), radius=0.525mm)
  A3_ext.subtract(A3_int)
  A4_ext = circle(normal=Z, centre=(142.9435mm, -6.9529417mm, -11.7mm), radius=1.515mm)
  A4_int = circle(normal=Z, centre=(142.9435mm, -6.9529417mm, -11.7mm), radius=0.525mm)
  A4_ext.subtract(A4_int)
  A5_ext = circle(normal=Z, centre=(148.46523mm, -23.947058mm, -11.7mm), radius=1.515mm)
  A5_int = circle(normal=Z, centre=(148.46523mm, -23.947058mm, -11.7mm), radius=0.525mm)
  A5_ext.subtract(A5_int)
  B_IN_ext = circle(normal=Z, centre=(134.00917mm, 19.25mm, -11.7mm), radius=1.515mm)
  B_IN_int = circle(normal=Z, centre=(134.00917mm, 19.25mm, -11.7mm), radius=0.525mm)
  B_IN_ext.subtract(B_IN_int)
  B1_ext = circle(normal=Z, centre=(119.55311mm, 23.947058mm, -11.7mm), radius=1.515mm)
  B1_int = circle(normal=Z, centre=(119.55311mm, 23.947058mm, -11.7mm), radius=0.525mm)
  B1_ext.subtract(B1_int)
  B2_ext = circle(normal=Z, centre=(125.07483mm, 6.9529417mm, -11.7mm), radius=1.515mm)
  B2_int = circle(normal=Z, centre=(125.07483mm, 6.9529417mm, -11.7mm), radius=0.525mm)
  B2_ext.subtract(B2_int)
  B3_ext = circle(normal=Z, centre=(134.00917mm, 34.45mm, -11.7mm), radius=1.515mm)
  B3_int = circle(normal=Z, centre=(134.00917mm, 34.45mm, -11.7mm), radius=0.525mm)
  B3_ext.subtract(B3_int)
  B4_ext = circle(normal=Z, centre=(142.9435mm, 6.9529417mm, -11.7mm), radius=1.515mm)
  B4_int = circle(normal=Z, centre=(142.9435mm, 6.9529417mm, -11.7mm), radius=0.525mm)
  B4_ext.subtract(B4_int)
  B5_ext = circle(normal=Z, centre=(148.46523mm, 23.947058mm, -11.7mm), radius=1.515mm)
  B5_int = circle(normal=Z, centre=(148.46523mm, 23.947058mm, -11.7mm), radius=0.525mm)
  B5_ext.subtract(B5_int)
  RadiatingSurface [vacuum] = region(absolute_offset=19.646365mm on all sides)
boundaries and excitations:
  ENIG_faces_expostas: Layered Impedance Faces=Estrela_Superior_A.face(at (133.608, -20.009, -9.9825), at (133.637, -24.9881, -9.9825), at (134.009, -20.7015, -9.965), at (133.532, -19.9635, -9.9825), at (132.855, -29.953, -9.9825), at (133.443, -19.8952, -9.9825), at (132.073, -32.2015, -9.9825), at (133.395, -19.8508, -9.9825), at (132.081, -34.5763, -9.9825), at (128.667, -21.3776, -9.9825), at (132.114, -34.8269, -9.9825), at (124.187, -23.6552, -9.9825)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) Estrela_Superior_B.face(at (125.929, 5.22031, -9.9825), at (126.148, 5.34666, -9.9825), at (134.009, 20.7015, -9.965), at (125.696, 5.12361, -9.9825), at (126.349, 5.5005, -9.9825), at (125.452, 5.05821, -9.9825), at (126.527, 5.67918, -9.9825), at (125.201, 5.02522, -9.9825), at (126.625, 5.79546, -9.9825), at (124.948, 5.02522, -9.9825), at (126.64, 5.81577, -9.9825), at (124.698, 5.05821, -9.9825)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) Massa_Superior.face(at (134.009, -38.48, -11.5375), at (115.029, 0, -11.5375), at (134.009, 38.48, -11.5375), at (152.989, 0, -11.5375), at (146.335, -23.9471, -11.5375), at (131.879, -34.45, -11.5375), at (131.879, -19.25, -11.5375), at (140.814, -6.95294, -11.5375), at (117.423, -23.9471, -11.5375), at (122.945, -6.95294, -11.5375), at (140.814, 6.95294, -11.5375), at (131.016, 2.65619, -11.5375)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) Pad_Superior_A1.face(at (118.823, -23.9471, -11.5375), at (119.028, -23.9471, -11.5375), at (119.553, -23.9471, -11.555)) Pad_Superior_A2.face(at (124.345, -6.95294, -11.5375), at (124.55, -6.95294, -11.5375), at (125.075, -6.95294, -11.555)) Pad_Superior_A3.face(at (133.279, -34.45, -11.5375), at (133.484, -34.45, -11.5375), at (134.009, -34.45, -11.555)) Pad_Superior_A4.face(at (142.214, -6.95294, -11.5375), at (142.419, -6.95294, -11.5375), at (142.944, -6.95294, -11.555)) Pad_Superior_A5.face(at (147.735, -23.9471, -11.5375), at (147.94, -23.9471, -11.5375), at (148.465, -23.9471, -11.555)) Pad_Superior_A_IN.face(at (133.279, -19.25, -11.5375), at (133.484, -19.25, -11.5375), at (134.009, -19.25, -11.555)) Pad_Superior_B1.face(at (118.823, 23.9471, -11.5375), at (119.028, 23.9471, -11.5375), at (119.553, 23.9471, -11.555)) Pad_Superior_B2.face(at (124.345, 6.95294, -11.5375), at (124.55, 6.95294, -11.5375), at (125.075, 6.95294, -11.555)) Pad_Superior_B3.face(at (133.279, 34.45, -11.5375), at (133.484, 34.45, -11.5375), at (134.009, 34.45, -11.555)) Pad_Superior_B4.face(at (142.214, 6.95294, -11.5375), at (142.419, 6.95294, -11.5375), at (142.944, 6.95294, -11.555)) Pad_Superior_B5.face(at (147.735, 23.9471, -11.5375), at (147.94, 23.9471, -11.5375), at (148.465, 23.9471, -11.555)) Pad_Superior_B_IN.face(at (133.279, 19.25, -11.5375), at (133.484, 19.25, -11.5375), at (134.009, 19.25, -11.555)) Frequency=0GHz Layers{Layer1{Thickness=0.0254um Material=Ouro_vol_nominal} Layer2{Thickness=4.5um Material=NiP_vol_nominal} Layer3{LayerType=1 Thickness=0 Material=Cobre_vol_Groiss}}
  Open1: Radiation Objects=RadiatingSurface
  A_IN: Lumped Port Objects=A_IN_ext LumpedPortType=Modal Modes{Mode1{IntLine{(134.53417, -19.25, -11.7) -> (135.52417, -19.25, -11.7)} CharImp=Zpi RenormImp=50ohm}} Impedance=50ohm
  A1: Lumped Port Objects=A1_ext LumpedPortType=Modal Modes{Mode1{IntLine{(120.07811, -23.947058, -11.7) -> (121.06811, -23.947058, -11.7)} CharImp=Zpi RenormImp=50ohm}} Impedance=50ohm
  A2: Lumped Port Objects=A2_ext LumpedPortType=Modal Modes{Mode1{IntLine{(125.59983, -6.9529417, -11.7) -> (126.58983, -6.9529417, -11.7)} CharImp=Zpi RenormImp=50ohm}} Impedance=50ohm
  A3: Lumped Port Objects=A3_ext LumpedPortType=Modal Modes{Mode1{IntLine{(134.53417, -34.45, -11.7) -> (135.52417, -34.45, -11.7)} CharImp=Zpi RenormImp=50ohm}} Impedance=50ohm
  A4: Lumped Port Objects=A4_ext LumpedPortType=Modal Modes{Mode1{IntLine{(143.4685, -6.9529417, -11.7) -> (144.4585, -6.9529417, -11.7)} CharImp=Zpi RenormImp=50ohm}} Impedance=50ohm
  A5: Lumped Port Objects=A5_ext LumpedPortType=Modal Modes{Mode1{IntLine{(148.99023, -23.947058, -11.7) -> (149.98023, -23.947058, -11.7)} CharImp=Zpi RenormImp=50ohm}} Impedance=50ohm
  B_IN: Lumped Port Objects=B_IN_ext LumpedPortType=Modal Modes{Mode1{IntLine{(134.53417, 19.25, -11.7) -> (135.52417, 19.25, -11.7)} CharImp=Zpi RenormImp=50ohm}} Impedance=50ohm
  B1: Lumped Port Objects=B1_ext LumpedPortType=Modal Modes{Mode1{IntLine{(120.07811, 23.947058, -11.7) -> (121.06811, 23.947058, -11.7)} CharImp=Zpi RenormImp=50ohm}} Impedance=50ohm
  B2: Lumped Port Objects=B2_ext LumpedPortType=Modal Modes{Mode1{IntLine{(125.59983, 6.9529417, -11.7) -> (126.58983, 6.9529417, -11.7)} CharImp=Zpi RenormImp=50ohm}} Impedance=50ohm
  B3: Lumped Port Objects=B3_ext LumpedPortType=Modal Modes{Mode1{IntLine{(134.53417, 34.45, -11.7) -> (135.52417, 34.45, -11.7)} CharImp=Zpi RenormImp=50ohm}} Impedance=50ohm
  B4: Lumped Port Objects=B4_ext LumpedPortType=Modal Modes{Mode1{IntLine{(143.4685, 6.9529417, -11.7) -> (144.4585, 6.9529417, -11.7)} CharImp=Zpi RenormImp=50ohm}} Impedance=50ohm
  B5: Lumped Port Objects=B5_ext LumpedPortType=Modal Modes{Mode1{IntLine{(148.99023, 23.947058, -11.7) -> (149.98023, 23.947058, -11.7)} CharImp=Zpi RenormImp=50ohm}} Impedance=50ohm
setups:
  Centro: HfssDriven Frequency=5.17GHz MaxDeltaS=0.008 MaximumPasses=16 MinimumPasses=3 MinimumConvergedPasses=2 PercentRefinement=24 BasisOrder=1 PortAccuracy=2 DrivenSolverType="Direct Solver"
    sweep Banda: 5090MHz to 5250MHz step 10MHz; Type=Discrete
source amplitudes:
  A_IN:1: 1W 0deg
  A1:1, A2:1, A3:1, A4:1, A5:1, B_IN:1, B1:1, B2:1, B3:1, B4:1, B5:1: 0W 0deg
radiation setups:
  3D: Infinite Sphere Theta=0deg..180deg step 2deg Phi=-180deg..180deg step 2deg
  Elevation: Infinite Sphere Theta=-180deg..180deg step 1deg Phi=0deg..90deg step 90deg
  Azimuth: Infinite Sphere Theta=90deg..90deg step 0deg Phi=-180deg..180deg step 1deg
