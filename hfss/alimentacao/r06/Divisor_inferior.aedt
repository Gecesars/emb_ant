# Ansys Electronics Desktop project, version 2024.2
materials:
  vacuum: permittivity=1
  ZYF300: permittivity=2.94 dielectric_loss_tangent=0.0016
  PTFE_terminal: permittivity=2.0363635 dielectric_loss_tangent=0.00027683055
  SAC305: conductivity=7575758
  copper: permeability=0.999991 conductivity=58000000
  NiP_vol_nominal: permeability=1 conductivity=1500000
  Ouro_vol_nominal: permeability=1 conductivity=41000000
  Cobre_vol_Groiss: permeability=1 conductivity=28688604

design Divisor_completo (HFSS, HFSS Hybrid Modal Network, model units mm)
geometry:
  Isol_terminal_RB2, Isol_terminal_RB1, Isol_terminal_RB_IN, Isol_terminal_RA2, Isol_terminal_RA1, Isol_terminal_RA_IN, Isol_terminal_B5, Isol_terminal_B4, Isol_terminal_B3, Isol_terminal_B2, Isol_terminal_B1, Isol_terminal_B_IN, Isol_terminal_A5, Isol_terminal_A4, Isol_terminal_A3, Isol_terminal_A2, Isol_terminal_A1, Isol_terminal_A_IN [PTFE_terminal] = imported_body(D:/dev/EMBRAER/P1H/R06_sem_cabos\divisor_inferior\cad\PTFE_terminal.step)
  Solda_Inferior_RB2, Solda_Inferior_RB1, Solda_Inferior_RA2, Solda_Inferior_RA1, Solda_Inferior_B5, Solda_Inferior_B4, Solda_Inferior_B3, Solda_Inferior_B2, Solda_Inferior_B1, Solda_Inferior_B_IN, Solda_Inferior_A5, Solda_Inferior_A4, Solda_Inferior_A3, Solda_Inferior_A2, Solda_Inferior_A1, Solda_Inferior_A_IN [SAC305] = imported_body(D:/dev/EMBRAER/P1H/R06_sem_cabos\divisor_inferior\cad\SAC305.step)
  ZYF300 [ZYF300] = imported_body(D:/dev/EMBRAER/P1H/R06_sem_cabos\divisor_inferior\cad\ZYF300.step)
  Massa_terminal_RB2, Terminal_RB2, Massa_terminal_RB1, Terminal_RB1, Massa_terminal_RB_IN, Terminal_RB_IN, Massa_terminal_RA2, Terminal_RA2, Massa_terminal_RA1, Terminal_RA1, Massa_terminal_RA_IN, Terminal_RA_IN, Massa_terminal_B5, Terminal_B5, Massa_terminal_B4, Terminal_B4, Massa_terminal_B3, Terminal_B3, Massa_terminal_B2, Terminal_B2, Massa_terminal_B1, Terminal_B1, Massa_terminal_B_IN, Terminal_B_IN, Massa_terminal_A5, Terminal_A5, Massa_terminal_A4, Terminal_A4, Massa_terminal_A3, Terminal_A3, Massa_terminal_A2, Terminal_A2, Massa_terminal_A1, Terminal_A1, Massa_terminal_A_IN, Terminal_A_IN [copper] = imported_body(D:/dev/EMBRAER/P1H/R06_sem_cabos\divisor_inferior\cad\copper.step)
  Estrela_Inferior_RB, Estrela_Inferior_RA, Estrela_Inferior_B, Estrela_Inferior_A, Massa_Inferior, Pad_Inferior_RB2, Pad_Inferior_RB1, Pad_Inferior_RB_IN, Pad_Inferior_RA2, Pad_Inferior_RA1, Pad_Inferior_RA_IN, Pad_Inferior_B5, Pad_Inferior_B4, Pad_Inferior_B3, Pad_Inferior_B2, Pad_Inferior_B1, Pad_Inferior_B_IN, Pad_Inferior_A5, Pad_Inferior_A4, Pad_Inferior_A3, Pad_Inferior_A2, Pad_Inferior_A1, Pad_Inferior_A_IN [Cobre_vol_Groiss] = imported_body(D:/dev/EMBRAER/P1H/R06_sem_cabos\divisor_inferior\cad\folha_cu.step)
  A_IN_ext = circle(normal=Z, centre=(-128.99083mm, -19.25mm, -11.7mm), radius=1.515mm)
  A_IN_int = circle(normal=Z, centre=(-128.99083mm, -19.25mm, -11.7mm), radius=0.525mm)
  A_IN_ext.subtract(A_IN_int)
  A1_ext = circle(normal=Z, centre=(-143.44689mm, -23.947058mm, -11.7mm), radius=1.515mm)
  A1_int = circle(normal=Z, centre=(-143.44689mm, -23.947058mm, -11.7mm), radius=0.525mm)
  A1_ext.subtract(A1_int)
  A2_ext = circle(normal=Z, centre=(-137.92517mm, -6.9529417mm, -11.7mm), radius=1.515mm)
  A2_int = circle(normal=Z, centre=(-137.92517mm, -6.9529417mm, -11.7mm), radius=0.525mm)
  A2_ext.subtract(A2_int)
  A3_ext = circle(normal=Z, centre=(-128.99083mm, -34.45mm, -11.7mm), radius=1.515mm)
  A3_int = circle(normal=Z, centre=(-128.99083mm, -34.45mm, -11.7mm), radius=0.525mm)
  A3_ext.subtract(A3_int)
  A4_ext = circle(normal=Z, centre=(-120.0565mm, -6.9529417mm, -11.7mm), radius=1.515mm)
  A4_int = circle(normal=Z, centre=(-120.0565mm, -6.9529417mm, -11.7mm), radius=0.525mm)
  A4_ext.subtract(A4_int)
  A5_ext = circle(normal=Z, centre=(-114.53477mm, -23.947058mm, -11.7mm), radius=1.515mm)
  A5_int = circle(normal=Z, centre=(-114.53477mm, -23.947058mm, -11.7mm), radius=0.525mm)
  A5_ext.subtract(A5_int)
  B_IN_ext = circle(normal=Z, centre=(-128.99083mm, 19.25mm, -11.7mm), radius=1.515mm)
  B_IN_int = circle(normal=Z, centre=(-128.99083mm, 19.25mm, -11.7mm), radius=0.525mm)
  B_IN_ext.subtract(B_IN_int)
  B1_ext = circle(normal=Z, centre=(-143.44689mm, 23.947058mm, -11.7mm), radius=1.515mm)
  B1_int = circle(normal=Z, centre=(-143.44689mm, 23.947058mm, -11.7mm), radius=0.525mm)
  B1_ext.subtract(B1_int)
  B2_ext = circle(normal=Z, centre=(-137.92517mm, 6.9529417mm, -11.7mm), radius=1.515mm)
  B2_int = circle(normal=Z, centre=(-137.92517mm, 6.9529417mm, -11.7mm), radius=0.525mm)
  B2_ext.subtract(B2_int)
  B3_ext = circle(normal=Z, centre=(-128.99083mm, 34.45mm, -11.7mm), radius=1.515mm)
  B3_int = circle(normal=Z, centre=(-128.99083mm, 34.45mm, -11.7mm), radius=0.525mm)
  B3_ext.subtract(B3_int)
  B4_ext = circle(normal=Z, centre=(-120.0565mm, 6.9529417mm, -11.7mm), radius=1.515mm)
  B4_int = circle(normal=Z, centre=(-120.0565mm, 6.9529417mm, -11.7mm), radius=0.525mm)
  B4_ext.subtract(B4_int)
  B5_ext = circle(normal=Z, centre=(-114.53477mm, 23.947058mm, -11.7mm), radius=1.515mm)
  B5_int = circle(normal=Z, centre=(-114.53477mm, 23.947058mm, -11.7mm), radius=0.525mm)
  B5_ext.subtract(B5_int)
  RA_IN_ext = circle(normal=Z, centre=(2.5091684mm, -19.25mm, -11.7mm), radius=1.515mm)
  RA_IN_int = circle(normal=Z, centre=(2.5091684mm, -19.25mm, -11.7mm), radius=0.525mm)
  RA_IN_ext.subtract(RA_IN_int)
  RA1_ext = circle(normal=Z, centre=(-12.690832mm, -19.25mm, -11.7mm), radius=1.515mm)
  RA1_int = circle(normal=Z, centre=(-12.690832mm, -19.25mm, -11.7mm), radius=0.525mm)
  RA1_ext.subtract(RA1_int)
  RA2_ext = circle(normal=Z, centre=(17.709168mm, -19.25mm, -11.7mm), radius=1.515mm)
  RA2_int = circle(normal=Z, centre=(17.709168mm, -19.25mm, -11.7mm), radius=0.525mm)
  RA2_ext.subtract(RA2_int)
  RB_IN_ext = circle(normal=Z, centre=(2.5091684mm, 19.25mm, -11.7mm), radius=1.515mm)
  RB_IN_int = circle(normal=Z, centre=(2.5091684mm, 19.25mm, -11.7mm), radius=0.525mm)
  RB_IN_ext.subtract(RB_IN_int)
  RB1_ext = circle(normal=Z, centre=(-12.690832mm, 19.25mm, -11.7mm), radius=1.515mm)
  RB1_int = circle(normal=Z, centre=(-12.690832mm, 19.25mm, -11.7mm), radius=0.525mm)
  RB1_ext.subtract(RB1_int)
  RB2_ext = circle(normal=Z, centre=(17.709168mm, 19.25mm, -11.7mm), radius=1.515mm)
  RB2_int = circle(normal=Z, centre=(17.709168mm, 19.25mm, -11.7mm), radius=0.525mm)
  RB2_ext.subtract(RB2_int)
  RadiatingSurface [vacuum] = region(absolute_offset=19.646365mm on all sides)
boundaries and excitations:
  ENIG_faces_expostas: Layered Impedance Faces=Estrela_Inferior_A.face(at (-129.392, -20.009, -9.9825), at (-129.363, -24.9881, -9.9825), at (-128.991, -20.7015, -9.965), at (-129.468, -19.9635, -9.9825), at (-130.145, -29.953, -9.9825), at (-129.557, -19.8952, -9.9825), at (-130.927, -32.2015, -9.9825), at (-129.605, -19.8508, -9.9825), at (-130.919, -34.5763, -9.9825), at (-134.333, -21.3776, -9.9825), at (-130.886, -34.8269, -9.9825), at (-138.813, -23.6552, -9.9825)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) Estrela_Inferior_B.face(at (-137.071, 5.22031, -9.9825), at (-136.852, 5.34666, -9.9825), at (-128.991, 20.7015, -9.965), at (-137.304, 5.12361, -9.9825), at (-136.651, 5.5005, -9.9825), at (-137.548, 5.05821, -9.9825), at (-136.473, 5.67918, -9.9825), at (-137.799, 5.02522, -9.9825), at (-136.375, 5.79546, -9.9825), at (-138.052, 5.02522, -9.9825), at (-136.36, 5.81577, -9.9825), at (-138.302, 5.05821, -9.9825)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) Estrela_Inferior_RA.face(at (-13.0677, -21.1447, -9.9825), at (-12.8172, -21.1777, -9.9825), at (2.50917, -19.25, -9.965), at (-13.3118, -21.0793, -9.9825), at (-10.2848, -21.186, -9.9825), at (-13.5453, -20.9826, -9.9825), at (-7.87883, -20.751, -9.9825), at (-13.7641, -20.8563, -9.9825), at (-2.98483, -20.316, -9.9825), at (-13.9646, -20.7024, -9.9825), at (1.90917, -20.0906, -9.9825), at (-14.1433, -20.5238, -9.9825)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) Estrela_Inferior_RB.face(at (-7.87883, 20.751, -9.9825), at (-10.2848, 21.186, -9.9825), at (2.50917, 19.25, -9.965), at (-2.98483, 20.316, -9.9825), at (-12.8172, 21.1777, -9.9825), at (1.90917, 20.0906, -9.9825), at (-13.0677, 21.1447, -9.9825), at (1.9474, 19.8988, -9.9825), at (-13.3118, 21.0793, -9.9825), at (2.0324, 19.9635, -9.9825), at (-13.5453, 20.9826, -9.9825), at (2.12961, 20.0197, -9.9825)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) Massa_Inferior.face(at (-128.991, -38.48, -11.5375), at (-110.011, -3.98, -11.5375), at (-147.971, 0, -11.5375), at (-63.2408, 0, -11.555), at (-63.2408, 30.52, -11.5375), at (-63.2408, 38.48, -11.5375), at (-16.4708, -3.98, -11.5375), at (21.4892, 0, -11.5375), at (2.50917, -38.48, -11.5375), at (15.5792, -19.25, -11.5375), at (-1.49083, -19.25, -11.5375), at (-14.8208, -19.25, -11.5375)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) Pad_Inferior_A1.face(at (-144.177, -23.9471, -11.5375), at (-143.972, -23.9471, -11.5375), at (-143.447, -23.9471, -11.555)) Pad_Inferior_A2.face(at (-138.655, -6.95294, -11.5375), at (-138.45, -6.95294, -11.5375), at (-137.925, -6.95294, -11.555)) Pad_Inferior_A3.face(at (-129.721, -34.45, -11.5375), at (-129.516, -34.45, -11.5375), at (-128.991, -34.45, -11.555)) Pad_Inferior_A4.face(at (-120.786, -6.95294, -11.5375), at (-120.581, -6.95294, -11.5375), at (-120.056, -6.95294, -11.555)) Pad_Inferior_A5.face(at (-115.265, -23.9471, -11.5375), at (-115.06, -23.9471, -11.5375), at (-114.535, -23.9471, -11.555)) Pad_Inferior_A_IN.face(at (-129.721, -19.25, -11.5375), at (-129.516, -19.25, -11.5375), at (-128.991, -19.25, -11.555)) Pad_Inferior_B1.face(at (-144.177, 23.9471, -11.5375), at (-143.972, 23.9471, -11.5375), at (-143.447, 23.9471, -11.555)) Pad_Inferior_B2.face(at (-138.655, 6.95294, -11.5375), at (-138.45, 6.95294, -11.5375), at (-137.925, 6.95294, -11.555)) Pad_Inferior_B3.face(at (-129.721, 34.45, -11.5375), at (-129.516, 34.45, -11.5375), at (-128.991, 34.45, -11.555)) Pad_Inferior_B4.face(at (-120.786, 6.95294, -11.5375), at (-120.581, 6.95294, -11.5375), at (-120.056, 6.95294, -11.555)) Pad_Inferior_B5.face(at (-115.265, 23.9471, -11.5375), at (-115.06, 23.9471, -11.5375), at (-114.535, 23.9471, -11.555)) Pad_Inferior_B_IN.face(at (-129.721, 19.25, -11.5375), at (-129.516, 19.25, -11.5375), at (-128.991, 19.25, -11.555)) Pad_Inferior_RA1.face(at (-13.4208, -19.25, -11.5375), at (-13.2158, -19.25, -11.5375), at (-12.6908, -19.25, -11.555)) Pad_Inferior_RA2.face(at (16.9792, -19.25, -11.5375), at (17.1842, -19.25, -11.5375), at (17.7092, -19.25, -11.555)) Pad_Inferior_RA_IN.face(at (1.77917, -19.25, -11.5375), at (1.98417, -19.25, -11.5375), at (2.50917, -19.25, -11.555)) Pad_Inferior_RB1.face(at (-13.4208, 19.25, -11.5375), at (-13.2158, 19.25, -11.5375), at (-12.6908, 19.25, -11.555)) Pad_Inferior_RB2.face(at (16.9792, 19.25, -11.5375), at (17.1842, 19.25, -11.5375), at (17.7092, 19.25, -11.555)) Pad_Inferior_RB_IN.face(at (1.77917, 19.25, -11.5375), at (1.98417, 19.25, -11.5375), at (2.50917, 19.25, -11.555)) Frequency=0GHz Layers{Layer1{Thickness=0.0254um Material=Ouro_vol_nominal} Layer2{Thickness=4.5um Material=NiP_vol_nominal} Layer3{LayerType=1 Thickness=0 Material=Cobre_vol_Groiss}}
  Open1: Radiation Objects=RadiatingSurface
  A_IN: Lumped Port Objects=A_IN_ext LumpedPortType=Modal Modes{Mode1{IntLine{(-128.46583, -19.25, -11.7) -> (-127.47583, -19.25, -11.7)} CharImp=Zpi RenormImp=50ohm}} Impedance=50ohm
  A1: Lumped Port Objects=A1_ext LumpedPortType=Modal Modes{Mode1{IntLine{(-142.92189, -23.947058, -11.7) -> (-141.93189, -23.947058, -11.7)} CharImp=Zpi RenormImp=50ohm}} Impedance=50ohm
  A2: Lumped Port Objects=A2_ext LumpedPortType=Modal Modes{Mode1{IntLine{(-137.40017, -6.9529417, -11.7) -> (-136.41017, -6.9529417, -11.7)} CharImp=Zpi RenormImp=50ohm}} Impedance=50ohm
  A3: Lumped Port Objects=A3_ext LumpedPortType=Modal Modes{Mode1{IntLine{(-128.46583, -34.45, -11.7) -> (-127.47583, -34.45, -11.7)} CharImp=Zpi RenormImp=50ohm}} Impedance=50ohm
  A4: Lumped Port Objects=A4_ext LumpedPortType=Modal Modes{Mode1{IntLine{(-119.5315, -6.9529417, -11.7) -> (-118.5415, -6.9529417, -11.7)} CharImp=Zpi RenormImp=50ohm}} Impedance=50ohm
  A5: Lumped Port Objects=A5_ext LumpedPortType=Modal Modes{Mode1{IntLine{(-114.00977, -23.947058, -11.7) -> (-113.01977, -23.947058, -11.7)} CharImp=Zpi RenormImp=50ohm}} Impedance=50ohm
  B_IN: Lumped Port Objects=B_IN_ext LumpedPortType=Modal Modes{Mode1{IntLine{(-128.46583, 19.25, -11.7) -> (-127.47583, 19.25, -11.7)} CharImp=Zpi RenormImp=50ohm}} Impedance=50ohm
  B1: Lumped Port Objects=B1_ext LumpedPortType=Modal Modes{Mode1{IntLine{(-142.92189, 23.947058, -11.7) -> (-141.93189, 23.947058, -11.7)} CharImp=Zpi RenormImp=50ohm}} Impedance=50ohm
  B2: Lumped Port Objects=B2_ext LumpedPortType=Modal Modes{Mode1{IntLine{(-137.40017, 6.9529417, -11.7) -> (-136.41017, 6.9529417, -11.7)} CharImp=Zpi RenormImp=50ohm}} Impedance=50ohm
  B3: Lumped Port Objects=B3_ext LumpedPortType=Modal Modes{Mode1{IntLine{(-128.46583, 34.45, -11.7) -> (-127.47583, 34.45, -11.7)} CharImp=Zpi RenormImp=50ohm}} Impedance=50ohm
  B4: Lumped Port Objects=B4_ext LumpedPortType=Modal Modes{Mode1{IntLine{(-119.5315, 6.9529417, -11.7) -> (-118.5415, 6.9529417, -11.7)} CharImp=Zpi RenormImp=50ohm}} Impedance=50ohm
  B5: Lumped Port Objects=B5_ext LumpedPortType=Modal Modes{Mode1{IntLine{(-114.00977, 23.947058, -11.7) -> (-113.01977, 23.947058, -11.7)} CharImp=Zpi RenormImp=50ohm}} Impedance=50ohm
  RA_IN: Lumped Port Objects=RA_IN_ext LumpedPortType=Modal Modes{Mode1{IntLine{(3.0341684, -19.25, -11.7) -> (4.0241684, -19.25, -11.7)} CharImp=Zpi RenormImp=50ohm}} Impedance=50ohm
  RA1: Lumped Port Objects=RA1_ext LumpedPortType=Modal Modes{Mode1{IntLine{(-12.165832, -19.25, -11.7) -> (-11.175832, -19.25, -11.7)} CharImp=Zpi RenormImp=50ohm}} Impedance=50ohm
  RA2: Lumped Port Objects=RA2_ext LumpedPortType=Modal Modes{Mode1{IntLine{(18.234168, -19.25, -11.7) -> (19.224168, -19.25, -11.7)} CharImp=Zpi RenormImp=50ohm}} Impedance=50ohm
  RB_IN: Lumped Port Objects=RB_IN_ext LumpedPortType=Modal Modes{Mode1{IntLine{(3.0341684, 19.25, -11.7) -> (4.0241684, 19.25, -11.7)} CharImp=Zpi RenormImp=50ohm}} Impedance=50ohm
  RB1: Lumped Port Objects=RB1_ext LumpedPortType=Modal Modes{Mode1{IntLine{(-12.165832, 19.25, -11.7) -> (-11.175832, 19.25, -11.7)} CharImp=Zpi RenormImp=50ohm}} Impedance=50ohm
  RB2: Lumped Port Objects=RB2_ext LumpedPortType=Modal Modes{Mode1{IntLine{(18.234168, 19.25, -11.7) -> (19.224168, 19.25, -11.7)} CharImp=Zpi RenormImp=50ohm}} Impedance=50ohm
setups:
  Centro: HfssDriven Frequency=5.17GHz MaxDeltaS=0.008 MaximumPasses=16 MinimumPasses=3 MinimumConvergedPasses=2 PercentRefinement=24 BasisOrder=1 PortAccuracy=2 DrivenSolverType="Direct Solver"
    sweep Banda: 5090MHz to 5250MHz step 10MHz; Type=Discrete
source amplitudes:
  A_IN:1: 1W 0deg
  A1:1, A2:1, A3:1, A4:1, A5:1, B_IN:1, B1:1, B2:1, B3:1, B4:1, B5:1, RA_IN:1, RA1:1, RA2:1, RB_IN:1, RB1:1, RB2:1: 0W 0deg
radiation setups:
  3D: Infinite Sphere Theta=0deg..180deg step 2deg Phi=-180deg..180deg step 2deg
  Elevation: Infinite Sphere Theta=-180deg..180deg step 1deg Phi=0deg..90deg step 90deg
  Azimuth: Infinite Sphere Theta=90deg..90deg step 0deg Phi=-180deg..180deg step 1deg
