# Ansys Electronics Desktop project, version 2024.2
materials:
  vacuum: permittivity=1
  LAM: permittivity=2.94 dielectric_loss_tangent=0.0016
  cabo: permittivity=2.036 dielectric_loss_tangent=0.000277
  SAC305: conductivity=7575758
  copper: permeability=0.999991 conductivity=58000000

design Rede_par (HFSS, HFSS Hybrid Modal Network, model units mm)
geometry:
  Laminado_Superior, Laminado_Inferior [LAM] = imported_body(D:\dev\EMBRAER\P1H\R03_Estudo\ZYF300CA-C\rede_hfss\LAM.step)
  Isol_E10, Isol_E09, Isol_E08, Isol_E07, Isol_E06, Isol_E05, Isol_E04, Isol_E03, Isol_E02, Isol_E01, Isol_IN [cabo] = imported_body(D:\dev\EMBRAER\P1H\R03_Estudo\ZYF300CA-C\rede_hfss\cabo.step)
  Capa_E10, Pino_E10, Capa_E09, Pino_E09, Capa_E08, Pino_E08, Capa_E07, Pino_E07, Capa_E06, Pino_E06, Capa_E05, Pino_E05, Capa_E04, Pino_E04, Capa_E03, Pino_E03, Capa_E02, Pino_E02, Capa_E01, Pino_E01, Capa_IN, Pino_IN, Emenda_massa, Emenda_sinal [copper] = imported_body(D:\dev\EMBRAER\P1H\R03_Estudo\ZYF300CA-C\rede_hfss\copper.step)
  Solda_E10, Solda_E09, Solda_E08, Solda_E07, Solda_E06, Solda_E05, Solda_E04, Solda_E03, Solda_E02, Solda_E01, Solda_IN [SAC305] = imported_body(D:\dev\EMBRAER\P1H\R03_Estudo\ZYF300CA-C\rede_hfss\SAC305.step)
  Rede_Superior, GND_Superior, Pad_E10, Pad_E09, Pad_E08, Pad_E07, Pad_E06, Rede_Inferior, GND_Inferior, Pad_E05, Pad_E04, Pad_E03, Pad_E02, Pad_E01, Pad_IN = imported_body(D:\dev\EMBRAER\P1H\R03_Estudo\ZYF300CA-C\rede_hfss\folha.step)
  Porta_IN = circle(normal=Z, centre=(-230mm, 31mm, -1.5mm), radius=1.515mm)
  Centro_IN = circle(normal=Z, centre=(-230mm, 31mm, -1.5mm), radius=0.45975mm)
  Porta_IN.subtract(Centro_IN)
  Porta_E01 = circle(normal=Z, centre=(-236.7mm, 2.509168413mm, -1.5mm), radius=1.515mm)
  Centro_E01 = circle(normal=Z, centre=(-236.7mm, 2.509168413mm, -1.5mm), radius=0.45975mm)
  Porta_E01.subtract(Centro_E01)
  Porta_E02 = circle(normal=Z, centre=(-184.1mm, 2.509168413mm, -1.5mm), radius=1.515mm)
  Centro_E02 = circle(normal=Z, centre=(-184.1mm, 2.509168413mm, -1.5mm), radius=0.45975mm)
  Porta_E02.subtract(Centro_E02)
  Porta_E03 = circle(normal=Z, centre=(-131.5mm, 2.509168413mm, -1.5mm), radius=1.515mm)
  Centro_E03 = circle(normal=Z, centre=(-131.5mm, 2.509168413mm, -1.5mm), radius=0.45975mm)
  Porta_E03.subtract(Centro_E03)
  Porta_E04 = circle(normal=Z, centre=(-78.9mm, 2.509168413mm, -1.5mm), radius=1.515mm)
  Centro_E04 = circle(normal=Z, centre=(-78.9mm, 2.509168413mm, -1.5mm), radius=0.45975mm)
  Porta_E04.subtract(Centro_E04)
  Porta_E05 = circle(normal=Z, centre=(-26.3mm, 2.509168413mm, -1.5mm), radius=1.515mm)
  Centro_E05 = circle(normal=Z, centre=(-26.3mm, 2.509168413mm, -1.5mm), radius=0.45975mm)
  Porta_E05.subtract(Centro_E05)
  Porta_E06 = circle(normal=Z, centre=(26.3mm, 2.509168413mm, -1.5mm), radius=1.515mm)
  Centro_E06 = circle(normal=Z, centre=(26.3mm, 2.509168413mm, -1.5mm), radius=0.45975mm)
  Porta_E06.subtract(Centro_E06)
  Porta_E07 = circle(normal=Z, centre=(78.9mm, 2.509168413mm, -1.5mm), radius=1.515mm)
  Centro_E07 = circle(normal=Z, centre=(78.9mm, 2.509168413mm, -1.5mm), radius=0.45975mm)
  Porta_E07.subtract(Centro_E07)
  Porta_E08 = circle(normal=Z, centre=(131.5mm, 2.509168413mm, -1.5mm), radius=1.515mm)
  Centro_E08 = circle(normal=Z, centre=(131.5mm, 2.509168413mm, -1.5mm), radius=0.45975mm)
  Porta_E08.subtract(Centro_E08)
  Porta_E09 = circle(normal=Z, centre=(184.1mm, 2.509168413mm, -1.5mm), radius=1.515mm)
  Centro_E09 = circle(normal=Z, centre=(184.1mm, 2.509168413mm, -1.5mm), radius=0.45975mm)
  Porta_E09.subtract(Centro_E09)
  Porta_E10 = circle(normal=Z, centre=(236.7mm, 2.509168413mm, -1.5mm), radius=1.515mm)
  Centro_E10 = circle(normal=Z, centre=(236.7mm, 2.509168413mm, -1.5mm), radius=0.45975mm)
  Porta_E10.subtract(Centro_E10)
  Region [vacuum] = region(absolute_offset: +X=18mm, -X=18mm, +Y=18mm, -Y=0mm, +Z=18mm, -Z=18mm)
boundaries and excitations:
  Cu_35um: Finite Conductivity Objects=[Pad_IN, Pad_E08, Pad_E09, GND_Inferior, Rede_Superior, Rede_Inferior, GND_Superior, Pad_E10, Pad_E04, Pad_E05, Pad_E06, Pad_E07, Pad_E01, Pad_E02, Pad_E03] UseMaterial Material=copper Thickness=0.035mm Roughness=0.5um IsInternal
  Radiacao: Radiation Faces=Region.face(+z, -x, +y, -z, +x)
  Simetria_magnetica: Symmetry Faces=Region.face(-y) IsPerfectE=false
  IN: Lumped Port Objects=Porta_IN LumpedPortType=Modal Modes{Mode1{IntLine{(-229.54025, 31, -1.5) -> (-228.485, 31, -1.5)} CharImp=Zpi RenormImp=50ohm}} Impedance=50ohm
  E01: Lumped Port Objects=Porta_E01 LumpedPortType=Modal Modes{Mode1{IntLine{(-236.24025, 2.509168413, -1.5) -> (-235.185, 2.509168413, -1.5)} CharImp=Zpi RenormImp=50ohm}} Impedance=50ohm
  E02: Lumped Port Objects=Porta_E02 LumpedPortType=Modal Modes{Mode1{IntLine{(-183.64025, 2.509168413, -1.5) -> (-182.585, 2.509168413, -1.5)} CharImp=Zpi RenormImp=50ohm}} Impedance=50ohm
  E03: Lumped Port Objects=Porta_E03 LumpedPortType=Modal Modes{Mode1{IntLine{(-131.04025, 2.509168413, -1.5) -> (-129.985, 2.509168413, -1.5)} CharImp=Zpi RenormImp=50ohm}} Impedance=50ohm
  E04: Lumped Port Objects=Porta_E04 LumpedPortType=Modal Modes{Mode1{IntLine{(-78.44025, 2.509168413, -1.5) -> (-77.385, 2.509168413, -1.5)} CharImp=Zpi RenormImp=50ohm}} Impedance=50ohm
  E05: Lumped Port Objects=Porta_E05 LumpedPortType=Modal Modes{Mode1{IntLine{(-25.84025, 2.509168413, -1.5) -> (-24.785, 2.509168413, -1.5)} CharImp=Zpi RenormImp=50ohm}} Impedance=50ohm
  E06: Lumped Port Objects=Porta_E06 LumpedPortType=Modal Modes{Mode1{IntLine{(26.75975, 2.509168413, -1.5) -> (27.815, 2.509168413, -1.5)} CharImp=Zpi RenormImp=50ohm}} Impedance=50ohm
  E07: Lumped Port Objects=Porta_E07 LumpedPortType=Modal Modes{Mode1{IntLine{(79.35975, 2.509168413, -1.5) -> (80.415, 2.509168413, -1.5)} CharImp=Zpi RenormImp=50ohm}} Impedance=50ohm
  E08: Lumped Port Objects=Porta_E08 LumpedPortType=Modal Modes{Mode1{IntLine{(131.95975, 2.509168413, -1.5) -> (133.015, 2.509168413, -1.5)} CharImp=Zpi RenormImp=50ohm}} Impedance=50ohm
  E09: Lumped Port Objects=Porta_E09 LumpedPortType=Modal Modes{Mode1{IntLine{(184.55975, 2.509168413, -1.5) -> (185.615, 2.509168413, -1.5)} CharImp=Zpi RenormImp=50ohm}} Impedance=50ohm
  E10: Lumped Port Objects=Porta_E10 LumpedPortType=Modal Modes{Mode1{IntLine{(237.15975, 2.509168413, -1.5) -> (238.215, 2.509168413, -1.5)} CharImp=Zpi RenormImp=50ohm}} Impedance=50ohm
setups:
  Rede: HfssDriven Frequency=5.17GHz MaxDeltaS=0.009 MaximumPasses=22 MinimumPasses=3 MinimumConvergedPasses=2 PercentRefinement=22 BasisOrder=1 PortAccuracy=2 DrivenSolverType="Iterative Solver" IterativeResidual=1e-05 DDMSolverResidual=1e-05
    sweep Banda: 5090MHz to 5250MHz step 10MHz; Type=Discrete
source amplitudes:
  IN:1: 1W 0deg
  E01:1, E02:1, E03:1, E04:1, E05:1, E06:1, E07:1, E08:1, E09:1, E10:1: 0W 0deg
