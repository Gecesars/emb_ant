# Ansys Electronics Desktop project, version 2024.2
materials:
  vacuum: permittivity=1
  ZYF300CA_C: permittivity=2.94 dielectric_loss_tangent=0.0016
  SAC305: permeability=1 conductivity=7575758
  PTFE_UT141: permittivity=2.036 dielectric_loss_tangent=0.0002
  copper: permeability=0.999991 conductivity=58000000

design Duplo_radial (HFSS, HFSS Hybrid Modal Network, model units mm)
geometry:
  Laminado [ZYF300CA_C] = box(corner=(-19.5mm, -39mm, 0mm), size=(39mm, 78mm, 1.52mm))
  GND = polyline(z=0mm, xy in mm: (-18.98, -38.48) (18.98, -38.48) (18.98, 38.48) (-18.98, 38.48) (-18.98, -38.48), closed, covered)
  Estrela_B = polyline(z=1.52mm, xy in mm: (1.67402711, 3.0835) (1.53355201, 2.87326416) (1.36683741, 2.68316259) (1.17673584, 2.51644799) (0.9665, 2.37597289) (0.73972707, 2.26414086) (0.50029721, 2.18286538) (0.25230713, 2.13353708) (0, 2.117) (-0.25230713, 2.13353708) (-0.50029721, 2.18286538) (-0.73972707, 2.26414086) (-0.9665, 2.37597289) (-1.17673584, 2.51644799) (-1.36683741, 2.68316259) (-1.53355201, 2.87326416) (-1.67402711, 3.0835) (-1.78585914, 3.31027293) (-1.86713462, 3.54970279) (-1.91646292, 3.79769287) (-1.933, 4.05) (-1.933, 8.315) (-0.11, 8.315) (-0.11, 18.39720978) (-0.11225253, 18.39735742) (-0.22258438, 18.41930379) (-0.32910775, 18.4554636) (-0.41170363, 18.49619538) (-6.33843986, 10.33874279) (-4.86360188, 9.26721027) (-7.37050598, 5.81675279) (-7.37265026, 5.8183107) (-7.40078383, 5.77620584) (-7.56749843, 5.58610428) (-7.75759999, 5.41938968) (-7.96783583, 5.27891458) (-8.19460876, 5.16708255) (-8.43403862, 5.08580706) (-8.68202871, 5.03647877) (-8.93433583, 5.01994169) (-9.18664296, 5.03647877) (-9.43463305, 5.08580706) (-9.67406291, 5.16708255) (-9.90083583, 5.27891458) (-10.11107168, 5.41938968) (-10.30117324, 5.58610428) (-10.46788784, 5.77620584) (-10.60836294, 5.98644169) (-10.72019497, 6.21321461) (-10.80147046, 6.45264447) (-10.85079875, 6.70063456) (-10.86733583, 6.95294169) (-10.85079875, 7.20524882) (-10.80147046, 7.4532389) (-10.72019497, 7.69266876) (-10.60836294, 7.91944169) (-10.49602141, 8.08757267) (-10.49816568, 8.08913058) (-7.99126158, 11.53958806) (-6.5164236, 10.46805554) (-0.58958876, 18.62564387) (-0.60811183, 18.64188817) (-0.68228387, 18.72646517) (-0.74478185, 18.82) (-0.77553132, 18.88235376) (-10.36581114, 15.76628295) (-9.80247316, 14.03250692) (-13.8587292, 12.71454944) (-13.85995706, 12.7183284) (-13.95576183, 12.68580706) (-14.20375192, 12.63647877) (-14.45605905, 12.61994169) (-14.70836618, 12.63647877) (-14.95635626, 12.68580706) (-15.19578612, 12.76708255) (-15.42255905, 12.87891458) (-15.63279489, 13.01938968) (-15.82289646, 13.18610428) (-15.98961105, 13.37620584) (-16.13008615, 13.58644169) (-16.24191818, 13.81321461) (-16.32319367, 14.05264447) (-16.37252196, 14.30063456) (-16.38905905, 14.55294169) (-16.37252196, 14.80524882) (-16.32319367, 15.0532389) (-16.24191818, 15.29266876) (-16.13008615, 15.51944169) (-15.98961105, 15.72967753) (-15.82289646, 15.91977909) (-15.63279489, 16.08649369) (-15.42255905, 16.22696879) (-15.19578612, 16.33880082) (-15.05216104, 16.38755497) (-15.0533889, 16.39133393) (-10.99713286, 17.70929141) (-10.43379488, 15.97551538) (-0.84346384, 19.09160283) (-0.85264258, 19.13774747) (-0.86, 19.25) (-0.85264258, 19.36225253) (-0.84346384, 19.40839717) (-10.43379488, 22.52448462) (-10.99713286, 20.79070859) (-15.0533889, 22.10866607) (-15.05216104, 22.11244503) (-15.19578612, 22.16119918) (-15.42255905, 22.27303121) (-15.63279489, 22.41350631) (-15.82289646, 22.58022091) (-15.98961105, 22.77032247) (-16.13008615, 22.98055831) (-16.24191818, 23.20733124) (-16.32319367, 23.4467611) (-16.37252196, 23.69475118) (-16.38905905, 23.94705831) (-16.37252196, 24.19936544) (-16.32319367, 24.44735553) (-16.24191818, 24.68678539) (-16.13008615, 24.91355831) (-15.98961105, 25.12379416) (-15.82289646, 25.31389572) (-15.63279489, 25.48061032) (-15.42255905, 25.62108542) (-15.19578612, 25.73291745) (-14.95635626, 25.81419294) (-14.70836618, 25.86352123) (-14.45605905, 25.88005831) (-14.20375192, 25.86352123) (-13.95576183, 25.81419294) (-13.85995706, 25.7816716) (-13.8587292, 25.78545056) (-9.80247316, 24.46749308) (-10.36581114, 22.73371705) (-0.77553132, 19.61764624) (-0.74478185, 19.68) (-0.68228387, 19.77353483) (-0.60811183, 19.85811183) (-0.58958876, 19.87435613) (-6.5164236, 28.03194446) (-7.99126158, 26.96041194) (-10.49816568, 30.41086942) (-10.49602141, 30.41242733) (-10.60836294, 30.58055831) (-10.72019497, 30.80733124) (-10.80147046, 31.0467611) (-10.85079875, 31.29475118) (-10.86733583, 31.54705831) (-10.85079875, 31.79936544) (-10.80147046, 32.04735553) (-10.72019497, 32.28678539) (-10.60836294, 32.51355831) (-10.46788784, 32.72379416) (-10.30117324, 32.91389572) (-10.11107168, 33.08061032) (-9.90083583, 33.22108542) (-9.67406291, 33.33291745) (-9.43463305, 33.41419294) (-9.18664296, 33.46352123) (-8.93433583, 33.48005831) (-8.68202871, 33.46352123) (-8.43403862, 33.41419294) (-8.19460876, 33.33291745) (-7.96783583, 33.22108542) (-7.75759999, 33.08061032) (-7.56749843, 32.91389572) (-7.40078383, 32.72379416) (-7.37265026, 32.6816893) (-7.37050598, 32.68324721) (-4.86360188, 29.23278973) (-6.33843986, 28.16125721) (-0.41170363, 20.00380462) (-0.32910775, 20.0445364) (-0.22258438, 20.08069621) (-0.11225253, 20.10264258) (-0.11, 20.10279022) (-0.11, 30.185) (-1.933, 30.185) (-1.933, 34.45) (-1.91646292, 34.70230713) (-1.86713462, 34.95029721) (-1.78585914, 35.18972707) (-1.67402711, 35.4165) (-1.53355201, 35.62673584) (-1.36683741, 35.81683741) (-1.17673584, 35.98355201) (-0.9665, 36.12402711) (-0.73972707, 36.23585914) (-0.50029721, 36.31713462) (-0.25230713, 36.36646292) (0, 36.383) (0.25230713, 36.36646292) (0.50029721, 36.31713462) (0.73972707, 36.23585914) (0.9665, 36.12402711) (1.17673584, 35.98355201) (1.36683741, 35.81683741) (1.53355201, 35.62673584) (1.67402711, 35.4165) (1.78585914, 35.18972707) (1.86713462, 34.95029721) (1.91646292, 34.70230713) (1.933, 34.45) (1.933, 30.185) (0.11, 30.185) (0.11, 20.10279022) (0.11225253, 20.10264258) (0.22258438, 20.08069621) (0.32910775, 20.0445364) (0.41170363, 20.00380462) (6.33843986, 28.16125721) (4.86360188, 29.23278973) (7.37050598, 32.68324721) (7.37265026, 32.6816893) (7.40078383, 32.72379416) (7.56749843, 32.91389572) (7.75759999, 33.08061032) (7.96783583, 33.22108542) (8.19460876, 33.33291745) (8.43403862, 33.41419294) (8.68202871, 33.46352123) (8.93433583, 33.48005831) (9.18664296, 33.46352123) (9.43463305, 33.41419294) (9.67406291, 33.33291745) (9.90083583, 33.22108542) (10.11107168, 33.08061032) (10.30117324, 32.91389572) (10.46788784, 32.72379416) (10.60836294, 32.51355831) (10.72019497, 32.28678539) (10.80147046, 32.04735553) (10.85079875, 31.79936544) (10.86733583, 31.54705831) (10.85079875, 31.29475118) (10.80147046, 31.0467611) (10.72019497, 30.80733124) (10.60836294, 30.58055831) (10.49602141, 30.41242733) (10.49816568, 30.41086942) (7.99126158, 26.96041194) (6.5164236, 28.03194446) (0.58958876, 19.87435613) (0.60811183, 19.85811183) (0.68228387, 19.77353483) (0.74478185, 19.68) (0.77553132, 19.61764624) (10.36581114, 22.73371705) (9.80247316, 24.46749308) (13.8587292, 25.78545056) (13.85995706, 25.7816716) (13.95576183, 25.81419294) (14.20375192, 25.86352123) (14.45605905, 25.88005831) (14.70836618, 25.86352123) (14.95635626, 25.81419294) (15.19578612, 25.73291745) (15.42255905, 25.62108542) (15.63279489, 25.48061032) (15.82289646, 25.31389572) (15.98961105, 25.12379416) (16.13008615, 24.91355831) (16.24191818, 24.68678539) (16.32319367, 24.44735553) (16.37252196, 24.19936544) (16.38905905, 23.94705831) (16.37252196, 23.69475118) (16.32319367, 23.4467611) (16.24191818, 23.20733124) (16.13008615, 22.98055831) (15.98961105, 22.77032247) (15.82289646, 22.58022091) (15.63279489, 22.41350631) (15.42255905, 22.27303121) (15.19578612, 22.16119918) (15.05216104, 22.11244503) (15.0533889, 22.10866607) (10.99713286, 20.79070859) (10.43379488, 22.52448462) (0.84346384, 19.40839717) (0.85264258, 19.36225253) (0.86, 19.25) (0.85264258, 19.13774747) (0.84346384, 19.09160283) (10.43379488, 15.97551538) (10.99713286, 17.70929141) (15.0533889, 16.39133393) (15.05216104, 16.38755497) (15.19578612, 16.33880082) (15.42255905, 16.22696879) (15.63279489, 16.08649369) (15.82289646, 15.91977909) (15.98961105, 15.72967753) (16.13008615, 15.51944169) (16.24191818, 15.29266876) (16.32319367, 15.0532389) (16.37252196, 14.80524882) (16.38905905, 14.55294169) (16.37252196, 14.30063456) (16.32319367, 14.05264447)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, closed, covered)
  Estrela_A = polyline(z=1.52mm, xy in mm: (1.67402711, -35.4165) (1.53355201, -35.62673584) (1.36683741, -35.81683741) (1.17673584, -35.98355201) (0.9665, -36.12402711) (0.73972707, -36.23585914) (0.50029721, -36.31713462) (0.25230713, -36.36646292) (0, -36.383) (-0.25230713, -36.36646292) (-0.50029721, -36.31713462) (-0.73972707, -36.23585914) (-0.9665, -36.12402711) (-1.17673584, -35.98355201) (-1.36683741, -35.81683741) (-1.53355201, -35.62673584) (-1.67402711, -35.4165) (-1.78585914, -35.18972707) (-1.86713462, -34.95029721) (-1.91646292, -34.70230713) (-1.933, -34.45) (-1.933, -30.185) (-0.11, -30.185) (-0.11, -20.10279022) (-0.11225253, -20.10264258) (-0.22258438, -20.08069621) (-0.32910775, -20.0445364) (-0.41170363, -20.00380462) (-6.33843986, -28.16125721) (-4.86360188, -29.23278973) (-7.37050598, -32.68324721) (-7.37265026, -32.6816893) (-7.40078383, -32.72379416) (-7.56749843, -32.91389572) (-7.75759999, -33.08061032) (-7.96783583, -33.22108542) (-8.19460876, -33.33291745) (-8.43403862, -33.41419294) (-8.68202871, -33.46352123) (-8.93433583, -33.48005831) (-9.18664296, -33.46352123) (-9.43463305, -33.41419294) (-9.67406291, -33.33291745) (-9.90083583, -33.22108542) (-10.11107168, -33.08061032) (-10.30117324, -32.91389572) (-10.46788784, -32.72379416) (-10.60836294, -32.51355831) (-10.72019497, -32.28678539) (-10.80147046, -32.04735553) (-10.85079875, -31.79936544) (-10.86733583, -31.54705831) (-10.85079875, -31.29475118) (-10.80147046, -31.0467611) (-10.72019497, -30.80733124) (-10.60836294, -30.58055831) (-10.49602141, -30.41242733) (-10.49816568, -30.41086942) (-7.99126158, -26.96041194) (-6.5164236, -28.03194446) (-0.58958876, -19.87435613) (-0.60811183, -19.85811183) (-0.68228387, -19.77353483) (-0.74478185, -19.68) (-0.77553132, -19.61764624) (-10.36581114, -22.73371705) (-9.80247316, -24.46749308) (-13.8587292, -25.78545056) (-13.85995706, -25.7816716) (-13.95576183, -25.81419294) (-14.20375192, -25.86352123) (-14.45605905, -25.88005831) (-14.70836618, -25.86352123) (-14.95635626, -25.81419294) (-15.19578612, -25.73291745) (-15.42255905, -25.62108542) (-15.63279489, -25.48061032) (-15.82289646, -25.31389572) (-15.98961105, -25.12379416) (-16.13008615, -24.91355831) (-16.24191818, -24.68678539) (-16.32319367, -24.44735553) (-16.37252196, -24.19936544) (-16.38905905, -23.94705831) (-16.37252196, -23.69475118) (-16.32319367, -23.4467611) (-16.24191818, -23.20733124) (-16.13008615, -22.98055831) (-15.98961105, -22.77032247) (-15.82289646, -22.58022091) (-15.63279489, -22.41350631) (-15.42255905, -22.27303121) (-15.19578612, -22.16119918) (-15.05216104, -22.11244503) (-15.0533889, -22.10866607) (-10.99713286, -20.79070859) (-10.43379488, -22.52448462) (-0.84346384, -19.40839717) (-0.85264258, -19.36225253) (-0.86, -19.25) (-0.85264258, -19.13774747) (-0.84346384, -19.09160283) (-10.43379488, -15.97551538) (-10.99713286, -17.70929141) (-15.0533889, -16.39133393) (-15.05216104, -16.38755497) (-15.19578612, -16.33880082) (-15.42255905, -16.22696879) (-15.63279489, -16.08649369) (-15.82289646, -15.91977909) (-15.98961105, -15.72967753) (-16.13008615, -15.51944169) (-16.24191818, -15.29266876) (-16.32319367, -15.0532389) (-16.37252196, -14.80524882) (-16.38905905, -14.55294169) (-16.37252196, -14.30063456) (-16.32319367, -14.05264447) (-16.24191818, -13.81321461) (-16.13008615, -13.58644169) (-15.98961105, -13.37620584) (-15.82289646, -13.18610428) (-15.63279489, -13.01938968) (-15.42255905, -12.87891458) (-15.19578612, -12.76708255) (-14.95635626, -12.68580706) (-14.70836618, -12.63647877) (-14.45605905, -12.61994169) (-14.20375192, -12.63647877) (-13.95576183, -12.68580706) (-13.85995706, -12.7183284) (-13.8587292, -12.71454944) (-9.80247316, -14.03250692) (-10.36581114, -15.76628295) (-0.77553132, -18.88235376) (-0.74478185, -18.82) (-0.68228387, -18.72646517) (-0.60811183, -18.64188817) (-0.58958876, -18.62564387) (-6.5164236, -10.46805554) (-7.99126158, -11.53958806) (-10.49816568, -8.08913058) (-10.49602141, -8.08757267) (-10.60836294, -7.91944169) (-10.72019497, -7.69266876) (-10.80147046, -7.4532389) (-10.85079875, -7.20524882) (-10.86733583, -6.95294169) (-10.85079875, -6.70063456) (-10.80147046, -6.45264447) (-10.72019497, -6.21321461) (-10.60836294, -5.98644169) (-10.46788784, -5.77620584) (-10.30117324, -5.58610428) (-10.11107168, -5.41938968) (-9.90083583, -5.27891458) (-9.67406291, -5.16708255) (-9.43463305, -5.08580706) (-9.18664296, -5.03647877) (-8.93433583, -5.01994169) (-8.68202871, -5.03647877) (-8.43403862, -5.08580706) (-8.19460876, -5.16708255) (-7.96783583, -5.27891458) (-7.75759999, -5.41938968) (-7.56749843, -5.58610428) (-7.40078383, -5.77620584) (-7.37265026, -5.8183107) (-7.37050598, -5.81675279) (-4.86360188, -9.26721027) (-6.33843986, -10.33874279) (-0.41170363, -18.49619538) (-0.32910775, -18.4554636) (-0.22258438, -18.41930379) (-0.11225253, -18.39735742) (-0.11, -18.39720978) (-0.11, -8.315) (-1.933, -8.315) (-1.933, -4.05) (-1.91646292, -3.79769287) (-1.86713462, -3.54970279) (-1.78585914, -3.31027293) (-1.67402711, -3.0835) (-1.53355201, -2.87326416) (-1.36683741, -2.68316259) (-1.17673584, -2.51644799) (-0.9665, -2.37597289) (-0.73972707, -2.26414086) (-0.50029721, -2.18286538) (-0.25230713, -2.13353708) (0, -2.117) (0.25230713, -2.13353708) (0.50029721, -2.18286538) (0.73972707, -2.26414086) (0.9665, -2.37597289) (1.17673584, -2.51644799) (1.36683741, -2.68316259) (1.53355201, -2.87326416) (1.67402711, -3.0835) (1.78585914, -3.31027293) (1.86713462, -3.54970279) (1.91646292, -3.79769287) (1.933, -4.05) (1.933, -8.315) (0.11, -8.315) (0.11, -18.39720978) (0.11225253, -18.39735742) (0.22258438, -18.41930379) (0.32910775, -18.4554636) (0.41170363, -18.49619538) (6.33843986, -10.33874279) (4.86360188, -9.26721027) (7.37050598, -5.81675279) (7.37265026, -5.8183107) (7.40078383, -5.77620584) (7.56749843, -5.58610428) (7.75759999, -5.41938968) (7.96783583, -5.27891458) (8.19460876, -5.16708255) (8.43403862, -5.08580706) (8.68202871, -5.03647877) (8.93433583, -5.01994169) (9.18664296, -5.03647877) (9.43463305, -5.08580706) (9.67406291, -5.16708255) (9.90083583, -5.27891458) (10.11107168, -5.41938968) (10.30117324, -5.58610428) (10.46788784, -5.77620584) (10.60836294, -5.98644169) (10.72019497, -6.21321461) (10.80147046, -6.45264447) (10.85079875, -6.70063456) (10.86733583, -6.95294169) (10.85079875, -7.20524882) (10.80147046, -7.4532389) (10.72019497, -7.69266876) (10.60836294, -7.91944169) (10.49602141, -8.08757267) (10.49816568, -8.08913058) (7.99126158, -11.53958806) (6.5164236, -10.46805554) (0.58958876, -18.62564387) (0.60811183, -18.64188817) (0.68228387, -18.72646517) (0.74478185, -18.82) (0.77553132, -18.88235376) (10.36581114, -15.76628295) (9.80247316, -14.03250692) (13.8587292, -12.71454944) (13.85995706, -12.7183284) (13.95576183, -12.68580706) (14.20375192, -12.63647877) (14.45605905, -12.61994169) (14.70836618, -12.63647877) (14.95635626, -12.68580706) (15.19578612, -12.76708255) (15.42255905, -12.87891458) (15.63279489, -13.01938968) (15.82289646, -13.18610428) (15.98961105, -13.37620584) (16.13008615, -13.58644169) (16.24191818, -13.81321461) (16.32319367, -14.05264447) (16.37252196, -14.30063456) (16.38905905, -14.55294169) (16.37252196, -14.80524882) (16.32319367, -15.0532389) (16.24191818, -15.29266876) (16.13008615, -15.51944169) (15.98961105, -15.72967753) (15.82289646, -15.91977909) (15.63279489, -16.08649369) (15.42255905, -16.22696879) (15.19578612, -16.33880082) (15.05216104, -16.38755497) (15.0533889, -16.39133393) (10.99713286, -17.70929141) (10.43379488, -15.97551538) (0.84346384, -19.09160283) (0.85264258, -19.13774747) (0.86, -19.25) (0.85264258, -19.36225253) (0.84346384, -19.40839717) (10.43379488, -22.52448462) (10.99713286, -20.79070859) (15.0533889, -22.10866607) (15.05216104, -22.11244503) (15.19578612, -22.16119918) (15.42255905, -22.27303121) (15.63279489, -22.41350631) (15.82289646, -22.58022091) (15.98961105, -22.77032247) (16.13008615, -22.98055831) (16.24191818, -23.20733124) (16.32319367, -23.4467611) (16.37252196, -23.69475118) (16.38905905, -23.94705831) (16.37252196, -24.19936544) (16.32319367, -24.44735553)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, closed, covered)
  Abertura_A_IN = circle(normal=Z, centre=(0mm, -19.25mm, 0mm), radius=1.515mm, segments=24)
  Pino_A_IN [copper] = cylinder(axis=Z, base_centre=(0mm, -19.25mm, 0mm), radius=0.525mm, height=1.52mm, segments=24)
  Anel_A_IN = circle(normal=Z, centre=(0mm, -19.25mm, 0mm), radius=0.73mm, segments=24)
  Blindagem_A_IN [copper] = cylinder(axis=Z, base_centre=(0mm, -19.25mm, -1.5mm), radius=1.7905mm, height=1.5mm, segments=24)
  PTFE_A_IN [PTFE_UT141] = cylinder(axis=Z, base_centre=(0mm, -19.25mm, -1.5mm), radius=1.515mm, height=1.5mm, segments=24)
  PTFE_A_IN_1 = PTFE_A_IN.copy()
  Blindagem_A_IN.subtract(PTFE_A_IN_1)
  Central_A_IN [copper] = cylinder(axis=Z, base_centre=(0mm, -19.25mm, -1.5mm), radius=0.45975mm, height=1.5mm, segments=24)
  Central_A_IN_1 = Central_A_IN.copy()
  PTFE_A_IN.subtract(Central_A_IN_1)
  Solda_ext_A_IN [SAC305] = cylinder(axis=Z, base_centre=(0mm, -19.25mm, -0.18mm), radius=2.13mm, height=0.18mm, segments=24)
  Recorte_ext_A_IN = cylinder(axis=Z, base_centre=(0mm, -19.25mm, -0.18mm), radius=1.7905mm, height=0.18mm, segments=24)
  Solda_ext_A_IN.subtract(Recorte_ext_A_IN)
  Solda_top_A_IN [SAC305] = cylinder(axis=Z, base_centre=(0mm, -19.25mm, 1.52mm), radius=0.74mm, height=0.17mm, segments=24)
  Abertura_A1 = circle(normal=Z, centre=(-14.45605905mm, -23.94705831mm, 0mm), radius=1.515mm, segments=24)
  Pino_A1 [copper] = cylinder(axis=Z, base_centre=(-14.45605905mm, -23.94705831mm, 0mm), radius=0.525mm, height=1.52mm, segments=24)
  Anel_A1 = circle(normal=Z, centre=(-14.45605905mm, -23.94705831mm, 0mm), radius=0.73mm, segments=24)
  Blindagem_A1 [copper] = cylinder(axis=Z, base_centre=(-14.45605905mm, -23.94705831mm, -1.5mm), radius=1.7905mm, height=1.5mm, segments=24)
  PTFE_A1 [PTFE_UT141] = cylinder(axis=Z, base_centre=(-14.45605905mm, -23.94705831mm, -1.5mm), radius=1.515mm, height=1.5mm, segments=24)
  PTFE_A1_1 = PTFE_A1.copy()
  Blindagem_A1.subtract(PTFE_A1_1)
  Central_A1 [copper] = cylinder(axis=Z, base_centre=(-14.45605905mm, -23.94705831mm, -1.5mm), radius=0.45975mm, height=1.5mm, segments=24)
  Central_A1_1 = Central_A1.copy()
  PTFE_A1.subtract(Central_A1_1)
  Solda_ext_A1 [SAC305] = cylinder(axis=Z, base_centre=(-14.45605905mm, -23.94705831mm, -0.18mm), radius=2.13mm, height=0.18mm, segments=24)
  Recorte_ext_A1 = cylinder(axis=Z, base_centre=(-14.45605905mm, -23.94705831mm, -0.18mm), radius=1.7905mm, height=0.18mm, segments=24)
  Solda_ext_A1.subtract(Recorte_ext_A1)
  Solda_top_A1 [SAC305] = cylinder(axis=Z, base_centre=(-14.45605905mm, -23.94705831mm, 1.52mm), radius=0.74mm, height=0.17mm, segments=24)
  Abertura_A2 = circle(normal=Z, centre=(-14.45605905mm, -14.55294169mm, 0mm), radius=1.515mm, segments=24)
  Pino_A2 [copper] = cylinder(axis=Z, base_centre=(-14.45605905mm, -14.55294169mm, 0mm), radius=0.525mm, height=1.52mm, segments=24)
  Anel_A2 = circle(normal=Z, centre=(-14.45605905mm, -14.55294169mm, 0mm), radius=0.73mm, segments=24)
  Blindagem_A2 [copper] = cylinder(axis=Z, base_centre=(-14.45605905mm, -14.55294169mm, -1.5mm), radius=1.7905mm, height=1.5mm, segments=24)
  PTFE_A2 [PTFE_UT141] = cylinder(axis=Z, base_centre=(-14.45605905mm, -14.55294169mm, -1.5mm), radius=1.515mm, height=1.5mm, segments=24)
  PTFE_A2_1 = PTFE_A2.copy()
  Blindagem_A2.subtract(PTFE_A2_1)
  Central_A2 [copper] = cylinder(axis=Z, base_centre=(-14.45605905mm, -14.55294169mm, -1.5mm), radius=0.45975mm, height=1.5mm, segments=24)
  Central_A2_1 = Central_A2.copy()
  PTFE_A2.subtract(Central_A2_1)
  Solda_ext_A2 [SAC305] = cylinder(axis=Z, base_centre=(-14.45605905mm, -14.55294169mm, -0.18mm), radius=2.13mm, height=0.18mm, segments=24)
  Recorte_ext_A2 = cylinder(axis=Z, base_centre=(-14.45605905mm, -14.55294169mm, -0.18mm), radius=1.7905mm, height=0.18mm, segments=24)
  Solda_ext_A2.subtract(Recorte_ext_A2)
  Solda_top_A2 [SAC305] = cylinder(axis=Z, base_centre=(-14.45605905mm, -14.55294169mm, 1.52mm), radius=0.74mm, height=0.17mm, segments=24)
  Abertura_A3 = circle(normal=Z, centre=(-8.93433583mm, -31.54705831mm, 0mm), radius=1.515mm, segments=24)
  Pino_A3 [copper] = cylinder(axis=Z, base_centre=(-8.93433583mm, -31.54705831mm, 0mm), radius=0.525mm, height=1.52mm, segments=24)
  Anel_A3 = circle(normal=Z, centre=(-8.93433583mm, -31.54705831mm, 0mm), radius=0.73mm, segments=24)
  Blindagem_A3 [copper] = cylinder(axis=Z, base_centre=(-8.93433583mm, -31.54705831mm, -1.5mm), radius=1.7905mm, height=1.5mm, segments=24)
  PTFE_A3 [PTFE_UT141] = cylinder(axis=Z, base_centre=(-8.93433583mm, -31.54705831mm, -1.5mm), radius=1.515mm, height=1.5mm, segments=24)
  PTFE_A3_1 = PTFE_A3.copy()
  Blindagem_A3.subtract(PTFE_A3_1)
  Central_A3 [copper] = cylinder(axis=Z, base_centre=(-8.93433583mm, -31.54705831mm, -1.5mm), radius=0.45975mm, height=1.5mm, segments=24)
  Central_A3_1 = Central_A3.copy()
  PTFE_A3.subtract(Central_A3_1)
  Solda_ext_A3 [SAC305] = cylinder(axis=Z, base_centre=(-8.93433583mm, -31.54705831mm, -0.18mm), radius=2.13mm, height=0.18mm, segments=24)
  Recorte_ext_A3 = cylinder(axis=Z, base_centre=(-8.93433583mm, -31.54705831mm, -0.18mm), radius=1.7905mm, height=0.18mm, segments=24)
  Solda_ext_A3.subtract(Recorte_ext_A3)
  Solda_top_A3 [SAC305] = cylinder(axis=Z, base_centre=(-8.93433583mm, -31.54705831mm, 1.52mm), radius=0.74mm, height=0.17mm, segments=24)
  Abertura_A4 = circle(normal=Z, centre=(-8.93433583mm, -6.95294169mm, 0mm), radius=1.515mm, segments=24)
  Pino_A4 [copper] = cylinder(axis=Z, base_centre=(-8.93433583mm, -6.95294169mm, 0mm), radius=0.525mm, height=1.52mm, segments=24)
  Anel_A4 = circle(normal=Z, centre=(-8.93433583mm, -6.95294169mm, 0mm), radius=0.73mm, segments=24)
  Blindagem_A4 [copper] = cylinder(axis=Z, base_centre=(-8.93433583mm, -6.95294169mm, -1.5mm), radius=1.7905mm, height=1.5mm, segments=24)
  PTFE_A4 [PTFE_UT141] = cylinder(axis=Z, base_centre=(-8.93433583mm, -6.95294169mm, -1.5mm), radius=1.515mm, height=1.5mm, segments=24)
  PTFE_A4_1 = PTFE_A4.copy()
  Blindagem_A4.subtract(PTFE_A4_1)
  Central_A4 [copper] = cylinder(axis=Z, base_centre=(-8.93433583mm, -6.95294169mm, -1.5mm), radius=0.45975mm, height=1.5mm, segments=24)
  Central_A4_1 = Central_A4.copy()
  PTFE_A4.subtract(Central_A4_1)
  Solda_ext_A4 [SAC305] = cylinder(axis=Z, base_centre=(-8.93433583mm, -6.95294169mm, -0.18mm), radius=2.13mm, height=0.18mm, segments=24)
  Recorte_ext_A4 = cylinder(axis=Z, base_centre=(-8.93433583mm, -6.95294169mm, -0.18mm), radius=1.7905mm, height=0.18mm, segments=24)
  Solda_ext_A4.subtract(Recorte_ext_A4)
  Solda_top_A4 [SAC305] = cylinder(axis=Z, base_centre=(-8.93433583mm, -6.95294169mm, 1.52mm), radius=0.74mm, height=0.17mm, segments=24)
  Abertura_A5 = circle(normal=Z, centre=(0mm, -34.45mm, 0mm), radius=1.515mm, segments=24)
  Pino_A5 [copper] = cylinder(axis=Z, base_centre=(0mm, -34.45mm, 0mm), radius=0.525mm, height=1.52mm, segments=24)
  Anel_A5 = circle(normal=Z, centre=(0mm, -34.45mm, 0mm), radius=0.73mm, segments=24)
  Blindagem_A5 [copper] = cylinder(axis=Z, base_centre=(0mm, -34.45mm, -1.5mm), radius=1.7905mm, height=1.5mm, segments=24)
  PTFE_A5 [PTFE_UT141] = cylinder(axis=Z, base_centre=(0mm, -34.45mm, -1.5mm), radius=1.515mm, height=1.5mm, segments=24)
  PTFE_A5_1 = PTFE_A5.copy()
  Blindagem_A5.subtract(PTFE_A5_1)
  Central_A5 [copper] = cylinder(axis=Z, base_centre=(0mm, -34.45mm, -1.5mm), radius=0.45975mm, height=1.5mm, segments=24)
  Central_A5_1 = Central_A5.copy()
  PTFE_A5.subtract(Central_A5_1)
  Solda_ext_A5 [SAC305] = cylinder(axis=Z, base_centre=(0mm, -34.45mm, -0.18mm), radius=2.13mm, height=0.18mm, segments=24)
  Recorte_ext_A5 = cylinder(axis=Z, base_centre=(0mm, -34.45mm, -0.18mm), radius=1.7905mm, height=0.18mm, segments=24)
  Solda_ext_A5.subtract(Recorte_ext_A5)
  Solda_top_A5 [SAC305] = cylinder(axis=Z, base_centre=(0mm, -34.45mm, 1.52mm), radius=0.74mm, height=0.17mm, segments=24)
  Abertura_A6 = circle(normal=Z, centre=(0mm, -4.05mm, 0mm), radius=1.515mm, segments=24)
  Pino_A6 [copper] = cylinder(axis=Z, base_centre=(0mm, -4.05mm, 0mm), radius=0.525mm, height=1.52mm, segments=24)
  Anel_A6 = circle(normal=Z, centre=(0mm, -4.05mm, 0mm), radius=0.73mm, segments=24)
  Blindagem_A6 [copper] = cylinder(axis=Z, base_centre=(0mm, -4.05mm, -1.5mm), radius=1.7905mm, height=1.5mm, segments=24)
  PTFE_A6 [PTFE_UT141] = cylinder(axis=Z, base_centre=(0mm, -4.05mm, -1.5mm), radius=1.515mm, height=1.5mm, segments=24)
  PTFE_A6_1 = PTFE_A6.copy()
  Blindagem_A6.subtract(PTFE_A6_1)
  Central_A6 [copper] = cylinder(axis=Z, base_centre=(0mm, -4.05mm, -1.5mm), radius=0.45975mm, height=1.5mm, segments=24)
  Central_A6_1 = Central_A6.copy()
  PTFE_A6.subtract(Central_A6_1)
  Solda_ext_A6 [SAC305] = cylinder(axis=Z, base_centre=(0mm, -4.05mm, -0.18mm), radius=2.13mm, height=0.18mm, segments=24)
  Recorte_ext_A6 = cylinder(axis=Z, base_centre=(0mm, -4.05mm, -0.18mm), radius=1.7905mm, height=0.18mm, segments=24)
  Solda_ext_A6.subtract(Recorte_ext_A6)
  Solda_top_A6 [SAC305] = cylinder(axis=Z, base_centre=(0mm, -4.05mm, 1.52mm), radius=0.74mm, height=0.17mm, segments=24)
  Abertura_A7 = circle(normal=Z, centre=(8.93433583mm, -31.54705831mm, 0mm), radius=1.515mm, segments=24)
  Pino_A7 [copper] = cylinder(axis=Z, base_centre=(8.93433583mm, -31.54705831mm, 0mm), radius=0.525mm, height=1.52mm, segments=24)
  Anel_A7 = circle(normal=Z, centre=(8.93433583mm, -31.54705831mm, 0mm), radius=0.73mm, segments=24)
  Blindagem_A7 [copper] = cylinder(axis=Z, base_centre=(8.93433583mm, -31.54705831mm, -1.5mm), radius=1.7905mm, height=1.5mm, segments=24)
  PTFE_A7 [PTFE_UT141] = cylinder(axis=Z, base_centre=(8.93433583mm, -31.54705831mm, -1.5mm), radius=1.515mm, height=1.5mm, segments=24)
  PTFE_A7_1 = PTFE_A7.copy()
  Blindagem_A7.subtract(PTFE_A7_1)
  Central_A7 [copper] = cylinder(axis=Z, base_centre=(8.93433583mm, -31.54705831mm, -1.5mm), radius=0.45975mm, height=1.5mm, segments=24)
  Central_A7_1 = Central_A7.copy()
  PTFE_A7.subtract(Central_A7_1)
  Solda_ext_A7 [SAC305] = cylinder(axis=Z, base_centre=(8.93433583mm, -31.54705831mm, -0.18mm), radius=2.13mm, height=0.18mm, segments=24)
  Recorte_ext_A7 = cylinder(axis=Z, base_centre=(8.93433583mm, -31.54705831mm, -0.18mm), radius=1.7905mm, height=0.18mm, segments=24)
  Solda_ext_A7.subtract(Recorte_ext_A7)
  Solda_top_A7 [SAC305] = cylinder(axis=Z, base_centre=(8.93433583mm, -31.54705831mm, 1.52mm), radius=0.74mm, height=0.17mm, segments=24)
  Abertura_A8 = circle(normal=Z, centre=(8.93433583mm, -6.95294169mm, 0mm), radius=1.515mm, segments=24)
  Pino_A8 [copper] = cylinder(axis=Z, base_centre=(8.93433583mm, -6.95294169mm, 0mm), radius=0.525mm, height=1.52mm, segments=24)
  Anel_A8 = circle(normal=Z, centre=(8.93433583mm, -6.95294169mm, 0mm), radius=0.73mm, segments=24)
  Blindagem_A8 [copper] = cylinder(axis=Z, base_centre=(8.93433583mm, -6.95294169mm, -1.5mm), radius=1.7905mm, height=1.5mm, segments=24)
  PTFE_A8 [PTFE_UT141] = cylinder(axis=Z, base_centre=(8.93433583mm, -6.95294169mm, -1.5mm), radius=1.515mm, height=1.5mm, segments=24)
  PTFE_A8_1 = PTFE_A8.copy()
  Blindagem_A8.subtract(PTFE_A8_1)
  Central_A8 [copper] = cylinder(axis=Z, base_centre=(8.93433583mm, -6.95294169mm, -1.5mm), radius=0.45975mm, height=1.5mm, segments=24)
  Central_A8_1 = Central_A8.copy()
  PTFE_A8.subtract(Central_A8_1)
  Solda_ext_A8 [SAC305] = cylinder(axis=Z, base_centre=(8.93433583mm, -6.95294169mm, -0.18mm), radius=2.13mm, height=0.18mm, segments=24)
  Recorte_ext_A8 = cylinder(axis=Z, base_centre=(8.93433583mm, -6.95294169mm, -0.18mm), radius=1.7905mm, height=0.18mm, segments=24)
  Solda_ext_A8.subtract(Recorte_ext_A8)
  Solda_top_A8 [SAC305] = cylinder(axis=Z, base_centre=(8.93433583mm, -6.95294169mm, 1.52mm), radius=0.74mm, height=0.17mm, segments=24)
  Abertura_A9 = circle(normal=Z, centre=(14.45605905mm, -23.94705831mm, 0mm), radius=1.515mm, segments=24)
  Pino_A9 [copper] = cylinder(axis=Z, base_centre=(14.45605905mm, -23.94705831mm, 0mm), radius=0.525mm, height=1.52mm, segments=24)
  Anel_A9 = circle(normal=Z, centre=(14.45605905mm, -23.94705831mm, 0mm), radius=0.73mm, segments=24)
  Blindagem_A9 [copper] = cylinder(axis=Z, base_centre=(14.45605905mm, -23.94705831mm, -1.5mm), radius=1.7905mm, height=1.5mm, segments=24)
  PTFE_A9 [PTFE_UT141] = cylinder(axis=Z, base_centre=(14.45605905mm, -23.94705831mm, -1.5mm), radius=1.515mm, height=1.5mm, segments=24)
  PTFE_A9_1 = PTFE_A9.copy()
  Blindagem_A9.subtract(PTFE_A9_1)
  Central_A9 [copper] = cylinder(axis=Z, base_centre=(14.45605905mm, -23.94705831mm, -1.5mm), radius=0.45975mm, height=1.5mm, segments=24)
  Central_A9_1 = Central_A9.copy()
  PTFE_A9.subtract(Central_A9_1)
  Solda_ext_A9 [SAC305] = cylinder(axis=Z, base_centre=(14.45605905mm, -23.94705831mm, -0.18mm), radius=2.13mm, height=0.18mm, segments=24)
  Recorte_ext_A9 = cylinder(axis=Z, base_centre=(14.45605905mm, -23.94705831mm, -0.18mm), radius=1.7905mm, height=0.18mm, segments=24)
  Solda_ext_A9.subtract(Recorte_ext_A9)
  Solda_top_A9 [SAC305] = cylinder(axis=Z, base_centre=(14.45605905mm, -23.94705831mm, 1.52mm), radius=0.74mm, height=0.17mm, segments=24)
  Abertura_A10 = circle(normal=Z, centre=(14.45605905mm, -14.55294169mm, 0mm), radius=1.515mm, segments=24)
  Pino_A10 [copper] = cylinder(axis=Z, base_centre=(14.45605905mm, -14.55294169mm, 0mm), radius=0.525mm, height=1.52mm, segments=24)
  Anel_A10 = circle(normal=Z, centre=(14.45605905mm, -14.55294169mm, 0mm), radius=0.73mm, segments=24)
  Blindagem_A10 [copper] = cylinder(axis=Z, base_centre=(14.45605905mm, -14.55294169mm, -1.5mm), radius=1.7905mm, height=1.5mm, segments=24)
  PTFE_A10 [PTFE_UT141] = cylinder(axis=Z, base_centre=(14.45605905mm, -14.55294169mm, -1.5mm), radius=1.515mm, height=1.5mm, segments=24)
  PTFE_A10_1 = PTFE_A10.copy()
  Blindagem_A10.subtract(PTFE_A10_1)
  Central_A10 [copper] = cylinder(axis=Z, base_centre=(14.45605905mm, -14.55294169mm, -1.5mm), radius=0.45975mm, height=1.5mm, segments=24)
  Central_A10_1 = Central_A10.copy()
  PTFE_A10.subtract(Central_A10_1)
  Solda_ext_A10 [SAC305] = cylinder(axis=Z, base_centre=(14.45605905mm, -14.55294169mm, -0.18mm), radius=2.13mm, height=0.18mm, segments=24)
  Recorte_ext_A10 = cylinder(axis=Z, base_centre=(14.45605905mm, -14.55294169mm, -0.18mm), radius=1.7905mm, height=0.18mm, segments=24)
  Solda_ext_A10.subtract(Recorte_ext_A10)
  Solda_top_A10 [SAC305] = cylinder(axis=Z, base_centre=(14.45605905mm, -14.55294169mm, 1.52mm), radius=0.74mm, height=0.17mm, segments=24)
  Abertura_B_IN = circle(normal=Z, centre=(0mm, 19.25mm, 0mm), radius=1.515mm, segments=24)
  Pino_B_IN [copper] = cylinder(axis=Z, base_centre=(0mm, 19.25mm, 0mm), radius=0.525mm, height=1.52mm, segments=24)
  Anel_B_IN = circle(normal=Z, centre=(0mm, 19.25mm, 0mm), radius=0.73mm, segments=24)
  Blindagem_B_IN [copper] = cylinder(axis=Z, base_centre=(0mm, 19.25mm, -1.5mm), radius=1.7905mm, height=1.5mm, segments=24)
  PTFE_B_IN [PTFE_UT141] = cylinder(axis=Z, base_centre=(0mm, 19.25mm, -1.5mm), radius=1.515mm, height=1.5mm, segments=24)
  PTFE_B_IN_1 = PTFE_B_IN.copy()
  Blindagem_B_IN.subtract(PTFE_B_IN_1)
  Central_B_IN [copper] = cylinder(axis=Z, base_centre=(0mm, 19.25mm, -1.5mm), radius=0.45975mm, height=1.5mm, segments=24)
  Central_B_IN_1 = Central_B_IN.copy()
  PTFE_B_IN.subtract(Central_B_IN_1)
  Solda_ext_B_IN [SAC305] = cylinder(axis=Z, base_centre=(0mm, 19.25mm, -0.18mm), radius=2.13mm, height=0.18mm, segments=24)
  Recorte_ext_B_IN = cylinder(axis=Z, base_centre=(0mm, 19.25mm, -0.18mm), radius=1.7905mm, height=0.18mm, segments=24)
  Solda_ext_B_IN.subtract(Recorte_ext_B_IN)
  Solda_top_B_IN [SAC305] = cylinder(axis=Z, base_centre=(0mm, 19.25mm, 1.52mm), radius=0.74mm, height=0.17mm, segments=24)
  Abertura_B1 = circle(normal=Z, centre=(-14.45605905mm, 14.55294169mm, 0mm), radius=1.515mm, segments=24)
  Pino_B1 [copper] = cylinder(axis=Z, base_centre=(-14.45605905mm, 14.55294169mm, 0mm), radius=0.525mm, height=1.52mm, segments=24)
  Anel_B1 = circle(normal=Z, centre=(-14.45605905mm, 14.55294169mm, 0mm), radius=0.73mm, segments=24)
  Blindagem_B1 [copper] = cylinder(axis=Z, base_centre=(-14.45605905mm, 14.55294169mm, -1.5mm), radius=1.7905mm, height=1.5mm, segments=24)
  PTFE_B1 [PTFE_UT141] = cylinder(axis=Z, base_centre=(-14.45605905mm, 14.55294169mm, -1.5mm), radius=1.515mm, height=1.5mm, segments=24)
  PTFE_B1_1 = PTFE_B1.copy()
  Blindagem_B1.subtract(PTFE_B1_1)
  Central_B1 [copper] = cylinder(axis=Z, base_centre=(-14.45605905mm, 14.55294169mm, -1.5mm), radius=0.45975mm, height=1.5mm, segments=24)
  Central_B1_1 = Central_B1.copy()
  PTFE_B1.subtract(Central_B1_1)
  Solda_ext_B1 [SAC305] = cylinder(axis=Z, base_centre=(-14.45605905mm, 14.55294169mm, -0.18mm), radius=2.13mm, height=0.18mm, segments=24)
  Recorte_ext_B1 = cylinder(axis=Z, base_centre=(-14.45605905mm, 14.55294169mm, -0.18mm), radius=1.7905mm, height=0.18mm, segments=24)
  Solda_ext_B1.subtract(Recorte_ext_B1)
  Solda_top_B1 [SAC305] = cylinder(axis=Z, base_centre=(-14.45605905mm, 14.55294169mm, 1.52mm), radius=0.74mm, height=0.17mm, segments=24)
  Abertura_B2 = circle(normal=Z, centre=(-14.45605905mm, 23.94705831mm, 0mm), radius=1.515mm, segments=24)
  Pino_B2 [copper] = cylinder(axis=Z, base_centre=(-14.45605905mm, 23.94705831mm, 0mm), radius=0.525mm, height=1.52mm, segments=24)
  Anel_B2 = circle(normal=Z, centre=(-14.45605905mm, 23.94705831mm, 0mm), radius=0.73mm, segments=24)
  Blindagem_B2 [copper] = cylinder(axis=Z, base_centre=(-14.45605905mm, 23.94705831mm, -1.5mm), radius=1.7905mm, height=1.5mm, segments=24)
  PTFE_B2 [PTFE_UT141] = cylinder(axis=Z, base_centre=(-14.45605905mm, 23.94705831mm, -1.5mm), radius=1.515mm, height=1.5mm, segments=24)
  PTFE_B2_1 = PTFE_B2.copy()
  Blindagem_B2.subtract(PTFE_B2_1)
  Central_B2 [copper] = cylinder(axis=Z, base_centre=(-14.45605905mm, 23.94705831mm, -1.5mm), radius=0.45975mm, height=1.5mm, segments=24)
  Central_B2_1 = Central_B2.copy()
  PTFE_B2.subtract(Central_B2_1)
  Solda_ext_B2 [SAC305] = cylinder(axis=Z, base_centre=(-14.45605905mm, 23.94705831mm, -0.18mm), radius=2.13mm, height=0.18mm, segments=24)
  Recorte_ext_B2 = cylinder(axis=Z, base_centre=(-14.45605905mm, 23.94705831mm, -0.18mm), radius=1.7905mm, height=0.18mm, segments=24)
  Solda_ext_B2.subtract(Recorte_ext_B2)
  Solda_top_B2 [SAC305] = cylinder(axis=Z, base_centre=(-14.45605905mm, 23.94705831mm, 1.52mm), radius=0.74mm, height=0.17mm, segments=24)
  Abertura_B3 = circle(normal=Z, centre=(-8.93433583mm, 6.95294169mm, 0mm), radius=1.515mm, segments=24)
  Pino_B3 [copper] = cylinder(axis=Z, base_centre=(-8.93433583mm, 6.95294169mm, 0mm), radius=0.525mm, height=1.52mm, segments=24)
  Anel_B3 = circle(normal=Z, centre=(-8.93433583mm, 6.95294169mm, 0mm), radius=0.73mm, segments=24)
  Blindagem_B3 [copper] = cylinder(axis=Z, base_centre=(-8.93433583mm, 6.95294169mm, -1.5mm), radius=1.7905mm, height=1.5mm, segments=24)
  PTFE_B3 [PTFE_UT141] = cylinder(axis=Z, base_centre=(-8.93433583mm, 6.95294169mm, -1.5mm), radius=1.515mm, height=1.5mm, segments=24)
  PTFE_B3_1 = PTFE_B3.copy()
  Blindagem_B3.subtract(PTFE_B3_1)
  Central_B3 [copper] = cylinder(axis=Z, base_centre=(-8.93433583mm, 6.95294169mm, -1.5mm), radius=0.45975mm, height=1.5mm, segments=24)
  Central_B3_1 = Central_B3.copy()
  PTFE_B3.subtract(Central_B3_1)
  Solda_ext_B3 [SAC305] = cylinder(axis=Z, base_centre=(-8.93433583mm, 6.95294169mm, -0.18mm), radius=2.13mm, height=0.18mm, segments=24)
  Recorte_ext_B3 = cylinder(axis=Z, base_centre=(-8.93433583mm, 6.95294169mm, -0.18mm), radius=1.7905mm, height=0.18mm, segments=24)
  Solda_ext_B3.subtract(Recorte_ext_B3)
  Solda_top_B3 [SAC305] = cylinder(axis=Z, base_centre=(-8.93433583mm, 6.95294169mm, 1.52mm), radius=0.74mm, height=0.17mm, segments=24)
  Abertura_B4 = circle(normal=Z, centre=(-8.93433583mm, 31.54705831mm, 0mm), radius=1.515mm, segments=24)
  Pino_B4 [copper] = cylinder(axis=Z, base_centre=(-8.93433583mm, 31.54705831mm, 0mm), radius=0.525mm, height=1.52mm, segments=24)
  Anel_B4 = circle(normal=Z, centre=(-8.93433583mm, 31.54705831mm, 0mm), radius=0.73mm, segments=24)
  Blindagem_B4 [copper] = cylinder(axis=Z, base_centre=(-8.93433583mm, 31.54705831mm, -1.5mm), radius=1.7905mm, height=1.5mm, segments=24)
  PTFE_B4 [PTFE_UT141] = cylinder(axis=Z, base_centre=(-8.93433583mm, 31.54705831mm, -1.5mm), radius=1.515mm, height=1.5mm, segments=24)
  PTFE_B4_1 = PTFE_B4.copy()
  Blindagem_B4.subtract(PTFE_B4_1)
  Central_B4 [copper] = cylinder(axis=Z, base_centre=(-8.93433583mm, 31.54705831mm, -1.5mm), radius=0.45975mm, height=1.5mm, segments=24)
  Central_B4_1 = Central_B4.copy()
  PTFE_B4.subtract(Central_B4_1)
  Solda_ext_B4 [SAC305] = cylinder(axis=Z, base_centre=(-8.93433583mm, 31.54705831mm, -0.18mm), radius=2.13mm, height=0.18mm, segments=24)
  Recorte_ext_B4 = cylinder(axis=Z, base_centre=(-8.93433583mm, 31.54705831mm, -0.18mm), radius=1.7905mm, height=0.18mm, segments=24)
  Solda_ext_B4.subtract(Recorte_ext_B4)
  Solda_top_B4 [SAC305] = cylinder(axis=Z, base_centre=(-8.93433583mm, 31.54705831mm, 1.52mm), radius=0.74mm, height=0.17mm, segments=24)
  Abertura_B5 = circle(normal=Z, centre=(0mm, 4.05mm, 0mm), radius=1.515mm, segments=24)
  Pino_B5 [copper] = cylinder(axis=Z, base_centre=(0mm, 4.05mm, 0mm), radius=0.525mm, height=1.52mm, segments=24)
  Anel_B5 = circle(normal=Z, centre=(0mm, 4.05mm, 0mm), radius=0.73mm, segments=24)
  Blindagem_B5 [copper] = cylinder(axis=Z, base_centre=(0mm, 4.05mm, -1.5mm), radius=1.7905mm, height=1.5mm, segments=24)
  PTFE_B5 [PTFE_UT141] = cylinder(axis=Z, base_centre=(0mm, 4.05mm, -1.5mm), radius=1.515mm, height=1.5mm, segments=24)
  PTFE_B5_1 = PTFE_B5.copy()
  Blindagem_B5.subtract(PTFE_B5_1)
  Central_B5 [copper] = cylinder(axis=Z, base_centre=(0mm, 4.05mm, -1.5mm), radius=0.45975mm, height=1.5mm, segments=24)
  Central_B5_1 = Central_B5.copy()
  PTFE_B5.subtract(Central_B5_1)
  Solda_ext_B5 [SAC305] = cylinder(axis=Z, base_centre=(0mm, 4.05mm, -0.18mm), radius=2.13mm, height=0.18mm, segments=24)
  Recorte_ext_B5 = cylinder(axis=Z, base_centre=(0mm, 4.05mm, -0.18mm), radius=1.7905mm, height=0.18mm, segments=24)
  Solda_ext_B5.subtract(Recorte_ext_B5)
  Solda_top_B5 [SAC305] = cylinder(axis=Z, base_centre=(0mm, 4.05mm, 1.52mm), radius=0.74mm, height=0.17mm, segments=24)
  Abertura_B6 = circle(normal=Z, centre=(0mm, 34.45mm, 0mm), radius=1.515mm, segments=24)
  Pino_B6 [copper] = cylinder(axis=Z, base_centre=(0mm, 34.45mm, 0mm), radius=0.525mm, height=1.52mm, segments=24)
  Anel_B6 = circle(normal=Z, centre=(0mm, 34.45mm, 0mm), radius=0.73mm, segments=24)
  Blindagem_B6 [copper] = cylinder(axis=Z, base_centre=(0mm, 34.45mm, -1.5mm), radius=1.7905mm, height=1.5mm, segments=24)
  PTFE_B6 [PTFE_UT141] = cylinder(axis=Z, base_centre=(0mm, 34.45mm, -1.5mm), radius=1.515mm, height=1.5mm, segments=24)
  PTFE_B6_1 = PTFE_B6.copy()
  Blindagem_B6.subtract(PTFE_B6_1)
  Central_B6 [copper] = cylinder(axis=Z, base_centre=(0mm, 34.45mm, -1.5mm), radius=0.45975mm, height=1.5mm, segments=24)
  Central_B6_1 = Central_B6.copy()
  PTFE_B6.subtract(Central_B6_1)
  Solda_ext_B6 [SAC305] = cylinder(axis=Z, base_centre=(0mm, 34.45mm, -0.18mm), radius=2.13mm, height=0.18mm, segments=24)
  Recorte_ext_B6 = cylinder(axis=Z, base_centre=(0mm, 34.45mm, -0.18mm), radius=1.7905mm, height=0.18mm, segments=24)
  Solda_ext_B6.subtract(Recorte_ext_B6)
  Solda_top_B6 [SAC305] = cylinder(axis=Z, base_centre=(0mm, 34.45mm, 1.52mm), radius=0.74mm, height=0.17mm, segments=24)
  Abertura_B7 = circle(normal=Z, centre=(8.93433583mm, 6.95294169mm, 0mm), radius=1.515mm, segments=24)
  Pino_B7 [copper] = cylinder(axis=Z, base_centre=(8.93433583mm, 6.95294169mm, 0mm), radius=0.525mm, height=1.52mm, segments=24)
  Anel_B7 = circle(normal=Z, centre=(8.93433583mm, 6.95294169mm, 0mm), radius=0.73mm, segments=24)
  Blindagem_B7 [copper] = cylinder(axis=Z, base_centre=(8.93433583mm, 6.95294169mm, -1.5mm), radius=1.7905mm, height=1.5mm, segments=24)
  PTFE_B7 [PTFE_UT141] = cylinder(axis=Z, base_centre=(8.93433583mm, 6.95294169mm, -1.5mm), radius=1.515mm, height=1.5mm, segments=24)
  PTFE_B7_1 = PTFE_B7.copy()
  Blindagem_B7.subtract(PTFE_B7_1)
  Central_B7 [copper] = cylinder(axis=Z, base_centre=(8.93433583mm, 6.95294169mm, -1.5mm), radius=0.45975mm, height=1.5mm, segments=24)
  Central_B7_1 = Central_B7.copy()
  PTFE_B7.subtract(Central_B7_1)
  Solda_ext_B7 [SAC305] = cylinder(axis=Z, base_centre=(8.93433583mm, 6.95294169mm, -0.18mm), radius=2.13mm, height=0.18mm, segments=24)
  Recorte_ext_B7 = cylinder(axis=Z, base_centre=(8.93433583mm, 6.95294169mm, -0.18mm), radius=1.7905mm, height=0.18mm, segments=24)
  Solda_ext_B7.subtract(Recorte_ext_B7)
  Solda_top_B7 [SAC305] = cylinder(axis=Z, base_centre=(8.93433583mm, 6.95294169mm, 1.52mm), radius=0.74mm, height=0.17mm, segments=24)
  Abertura_B8 = circle(normal=Z, centre=(8.93433583mm, 31.54705831mm, 0mm), radius=1.515mm, segments=24)
  Pino_B8 [copper] = cylinder(axis=Z, base_centre=(8.93433583mm, 31.54705831mm, 0mm), radius=0.525mm, height=1.52mm, segments=24)
  Anel_B8 = circle(normal=Z, centre=(8.93433583mm, 31.54705831mm, 0mm), radius=0.73mm, segments=24)
  Blindagem_B8 [copper] = cylinder(axis=Z, base_centre=(8.93433583mm, 31.54705831mm, -1.5mm), radius=1.7905mm, height=1.5mm, segments=24)
  PTFE_B8 [PTFE_UT141] = cylinder(axis=Z, base_centre=(8.93433583mm, 31.54705831mm, -1.5mm), radius=1.515mm, height=1.5mm, segments=24)
  PTFE_B8_1 = PTFE_B8.copy()
  Blindagem_B8.subtract(PTFE_B8_1)
  Central_B8 [copper] = cylinder(axis=Z, base_centre=(8.93433583mm, 31.54705831mm, -1.5mm), radius=0.45975mm, height=1.5mm, segments=24)
  Central_B8_1 = Central_B8.copy()
  PTFE_B8.subtract(Central_B8_1)
  Solda_ext_B8 [SAC305] = cylinder(axis=Z, base_centre=(8.93433583mm, 31.54705831mm, -0.18mm), radius=2.13mm, height=0.18mm, segments=24)
  Recorte_ext_B8 = cylinder(axis=Z, base_centre=(8.93433583mm, 31.54705831mm, -0.18mm), radius=1.7905mm, height=0.18mm, segments=24)
  Solda_ext_B8.subtract(Recorte_ext_B8)
  Solda_top_B8 [SAC305] = cylinder(axis=Z, base_centre=(8.93433583mm, 31.54705831mm, 1.52mm), radius=0.74mm, height=0.17mm, segments=24)
  Abertura_B9 = circle(normal=Z, centre=(14.45605905mm, 14.55294169mm, 0mm), radius=1.515mm, segments=24)
  Pino_B9 [copper] = cylinder(axis=Z, base_centre=(14.45605905mm, 14.55294169mm, 0mm), radius=0.525mm, height=1.52mm, segments=24)
  Anel_B9 = circle(normal=Z, centre=(14.45605905mm, 14.55294169mm, 0mm), radius=0.73mm, segments=24)
  Blindagem_B9 [copper] = cylinder(axis=Z, base_centre=(14.45605905mm, 14.55294169mm, -1.5mm), radius=1.7905mm, height=1.5mm, segments=24)
  PTFE_B9 [PTFE_UT141] = cylinder(axis=Z, base_centre=(14.45605905mm, 14.55294169mm, -1.5mm), radius=1.515mm, height=1.5mm, segments=24)
  PTFE_B9_1 = PTFE_B9.copy()
  Blindagem_B9.subtract(PTFE_B9_1)
  Central_B9 [copper] = cylinder(axis=Z, base_centre=(14.45605905mm, 14.55294169mm, -1.5mm), radius=0.45975mm, height=1.5mm, segments=24)
  Central_B9_1 = Central_B9.copy()
  PTFE_B9.subtract(Central_B9_1)
  Solda_ext_B9 [SAC305] = cylinder(axis=Z, base_centre=(14.45605905mm, 14.55294169mm, -0.18mm), radius=2.13mm, height=0.18mm, segments=24)
  Recorte_ext_B9 = cylinder(axis=Z, base_centre=(14.45605905mm, 14.55294169mm, -0.18mm), radius=1.7905mm, height=0.18mm, segments=24)
  Solda_ext_B9.subtract(Recorte_ext_B9)
  Solda_top_B9 [SAC305] = cylinder(axis=Z, base_centre=(14.45605905mm, 14.55294169mm, 1.52mm), radius=0.74mm, height=0.17mm, segments=24)
  Abertura_B10 = circle(normal=Z, centre=(14.45605905mm, 23.94705831mm, 0mm), radius=1.515mm, segments=24)
  Pino_B10 [copper] = cylinder(axis=Z, base_centre=(14.45605905mm, 23.94705831mm, 0mm), radius=0.525mm, height=1.52mm, segments=24)
  Anel_B10 = circle(normal=Z, centre=(14.45605905mm, 23.94705831mm, 0mm), radius=0.73mm, segments=24)
  Blindagem_B10 [copper] = cylinder(axis=Z, base_centre=(14.45605905mm, 23.94705831mm, -1.5mm), radius=1.7905mm, height=1.5mm, segments=24)
  PTFE_B10 [PTFE_UT141] = cylinder(axis=Z, base_centre=(14.45605905mm, 23.94705831mm, -1.5mm), radius=1.515mm, height=1.5mm, segments=24)
  PTFE_B10_1 = PTFE_B10.copy()
  Blindagem_B10.subtract(PTFE_B10_1)
  Central_B10 [copper] = cylinder(axis=Z, base_centre=(14.45605905mm, 23.94705831mm, -1.5mm), radius=0.45975mm, height=1.5mm, segments=24)
  Central_B10_1 = Central_B10.copy()
  PTFE_B10.subtract(Central_B10_1)
  Solda_ext_B10 [SAC305] = cylinder(axis=Z, base_centre=(14.45605905mm, 23.94705831mm, -0.18mm), radius=2.13mm, height=0.18mm, segments=24)
  Recorte_ext_B10 = cylinder(axis=Z, base_centre=(14.45605905mm, 23.94705831mm, -0.18mm), radius=1.7905mm, height=0.18mm, segments=24)
  Solda_ext_B10.subtract(Recorte_ext_B10)
  Solda_top_B10 [SAC305] = cylinder(axis=Z, base_centre=(14.45605905mm, 23.94705831mm, 1.52mm), radius=0.74mm, height=0.17mm, segments=24)
  GND.subtract(Abertura_A_IN, Abertura_A1..Abertura_A10, Abertura_B_IN, Abertura_B1..Abertura_B10)
  Pino_A_IN_1 = Pino_A_IN.copy()
  Pino_A1_1 = Pino_A1.copy()
  Pino_A2_1 = Pino_A2.copy()
  Pino_A3_1 = Pino_A3.copy()
  Pino_A4_1 = Pino_A4.copy()
  Pino_A5_1 = Pino_A5.copy()
  Pino_A6_1 = Pino_A6.copy()
  Pino_A7_1 = Pino_A7.copy()
  Pino_A8_1 = Pino_A8.copy()
  Pino_A9_1 = Pino_A9.copy()
  Pino_A10_1 = Pino_A10.copy()
  Pino_B_IN_1 = Pino_B_IN.copy()
  Pino_B1_1 = Pino_B1.copy()
  Pino_B2_1 = Pino_B2.copy()
  Pino_B3_1 = Pino_B3.copy()
  Pino_B4_1 = Pino_B4.copy()
  Pino_B5_1 = Pino_B5.copy()
  Pino_B6_1 = Pino_B6.copy()
  Pino_B7_1 = Pino_B7.copy()
  Pino_B8_1 = Pino_B8.copy()
  Pino_B9_1 = Pino_B9.copy()
  Pino_B10_1 = Pino_B10.copy()
  Laminado.subtract(Pino_A_IN_1, Pino_A1_1, Pino_A2_1, Pino_A3_1, Pino_A4_1, Pino_A5_1, Pino_A6_1, Pino_A7_1, Pino_A8_1, Pino_A9_1, Pino_A10_1, Pino_B_IN_1, Pino_B1_1, Pino_B2_1, Pino_B3_1, Pino_B4_1, Pino_B5_1, Pino_B6_1, Pino_B7_1, Pino_B8_1, Pino_B9_1, Pino_B10_1)
  Porta_A_IN = circle(normal=Z, centre=(0mm, -19.25mm, -1.5mm), radius=1.515mm, segments=24)
  Buraco_A_IN = circle(normal=Z, centre=(0mm, -19.25mm, -1.5mm), radius=0.45975mm, segments=24)
  Porta_A_IN.subtract(Buraco_A_IN)
  Porta_A1 = circle(normal=Z, centre=(-14.45605905mm, -23.94705831mm, -1.5mm), radius=1.515mm, segments=24)
  Buraco_A1 = circle(normal=Z, centre=(-14.45605905mm, -23.94705831mm, -1.5mm), radius=0.45975mm, segments=24)
  Porta_A1.subtract(Buraco_A1)
  Porta_A2 = circle(normal=Z, centre=(-14.45605905mm, -14.55294169mm, -1.5mm), radius=1.515mm, segments=24)
  Buraco_A2 = circle(normal=Z, centre=(-14.45605905mm, -14.55294169mm, -1.5mm), radius=0.45975mm, segments=24)
  Porta_A2.subtract(Buraco_A2)
  Porta_A3 = circle(normal=Z, centre=(-8.93433583mm, -31.54705831mm, -1.5mm), radius=1.515mm, segments=24)
  Buraco_A3 = circle(normal=Z, centre=(-8.93433583mm, -31.54705831mm, -1.5mm), radius=0.45975mm, segments=24)
  Porta_A3.subtract(Buraco_A3)
  Porta_A4 = circle(normal=Z, centre=(-8.93433583mm, -6.95294169mm, -1.5mm), radius=1.515mm, segments=24)
  Buraco_A4 = circle(normal=Z, centre=(-8.93433583mm, -6.95294169mm, -1.5mm), radius=0.45975mm, segments=24)
  Porta_A4.subtract(Buraco_A4)
  Porta_A5 = circle(normal=Z, centre=(0mm, -34.45mm, -1.5mm), radius=1.515mm, segments=24)
  Buraco_A5 = circle(normal=Z, centre=(0mm, -34.45mm, -1.5mm), radius=0.45975mm, segments=24)
  Porta_A5.subtract(Buraco_A5)
  Porta_A6 = circle(normal=Z, centre=(0mm, -4.05mm, -1.5mm), radius=1.515mm, segments=24)
  Buraco_A6 = circle(normal=Z, centre=(0mm, -4.05mm, -1.5mm), radius=0.45975mm, segments=24)
  Porta_A6.subtract(Buraco_A6)
  Porta_A7 = circle(normal=Z, centre=(8.93433583mm, -31.54705831mm, -1.5mm), radius=1.515mm, segments=24)
  Buraco_A7 = circle(normal=Z, centre=(8.93433583mm, -31.54705831mm, -1.5mm), radius=0.45975mm, segments=24)
  Porta_A7.subtract(Buraco_A7)
  Porta_A8 = circle(normal=Z, centre=(8.93433583mm, -6.95294169mm, -1.5mm), radius=1.515mm, segments=24)
  Buraco_A8 = circle(normal=Z, centre=(8.93433583mm, -6.95294169mm, -1.5mm), radius=0.45975mm, segments=24)
  Porta_A8.subtract(Buraco_A8)
  Porta_A9 = circle(normal=Z, centre=(14.45605905mm, -23.94705831mm, -1.5mm), radius=1.515mm, segments=24)
  Buraco_A9 = circle(normal=Z, centre=(14.45605905mm, -23.94705831mm, -1.5mm), radius=0.45975mm, segments=24)
  Porta_A9.subtract(Buraco_A9)
  Porta_A10 = circle(normal=Z, centre=(14.45605905mm, -14.55294169mm, -1.5mm), radius=1.515mm, segments=24)
  Buraco_A10 = circle(normal=Z, centre=(14.45605905mm, -14.55294169mm, -1.5mm), radius=0.45975mm, segments=24)
  Porta_A10.subtract(Buraco_A10)
  Porta_B_IN = circle(normal=Z, centre=(0mm, 19.25mm, -1.5mm), radius=1.515mm, segments=24)
  Buraco_B_IN = circle(normal=Z, centre=(0mm, 19.25mm, -1.5mm), radius=0.45975mm, segments=24)
  Porta_B_IN.subtract(Buraco_B_IN)
  Porta_B1 = circle(normal=Z, centre=(-14.45605905mm, 14.55294169mm, -1.5mm), radius=1.515mm, segments=24)
  Buraco_B1 = circle(normal=Z, centre=(-14.45605905mm, 14.55294169mm, -1.5mm), radius=0.45975mm, segments=24)
  Porta_B1.subtract(Buraco_B1)
  Porta_B2 = circle(normal=Z, centre=(-14.45605905mm, 23.94705831mm, -1.5mm), radius=1.515mm, segments=24)
  Buraco_B2 = circle(normal=Z, centre=(-14.45605905mm, 23.94705831mm, -1.5mm), radius=0.45975mm, segments=24)
  Porta_B2.subtract(Buraco_B2)
  Porta_B3 = circle(normal=Z, centre=(-8.93433583mm, 6.95294169mm, -1.5mm), radius=1.515mm, segments=24)
  Buraco_B3 = circle(normal=Z, centre=(-8.93433583mm, 6.95294169mm, -1.5mm), radius=0.45975mm, segments=24)
  Porta_B3.subtract(Buraco_B3)
  Porta_B4 = circle(normal=Z, centre=(-8.93433583mm, 31.54705831mm, -1.5mm), radius=1.515mm, segments=24)
  Buraco_B4 = circle(normal=Z, centre=(-8.93433583mm, 31.54705831mm, -1.5mm), radius=0.45975mm, segments=24)
  Porta_B4.subtract(Buraco_B4)
  Porta_B5 = circle(normal=Z, centre=(0mm, 4.05mm, -1.5mm), radius=1.515mm, segments=24)
  Buraco_B5 = circle(normal=Z, centre=(0mm, 4.05mm, -1.5mm), radius=0.45975mm, segments=24)
  Porta_B5.subtract(Buraco_B5)
  Porta_B6 = circle(normal=Z, centre=(0mm, 34.45mm, -1.5mm), radius=1.515mm, segments=24)
  Buraco_B6 = circle(normal=Z, centre=(0mm, 34.45mm, -1.5mm), radius=0.45975mm, segments=24)
  Porta_B6.subtract(Buraco_B6)
  Porta_B7 = circle(normal=Z, centre=(8.93433583mm, 6.95294169mm, -1.5mm), radius=1.515mm, segments=24)
  Buraco_B7 = circle(normal=Z, centre=(8.93433583mm, 6.95294169mm, -1.5mm), radius=0.45975mm, segments=24)
  Porta_B7.subtract(Buraco_B7)
  Porta_B8 = circle(normal=Z, centre=(8.93433583mm, 31.54705831mm, -1.5mm), radius=1.515mm, segments=24)
  Buraco_B8 = circle(normal=Z, centre=(8.93433583mm, 31.54705831mm, -1.5mm), radius=0.45975mm, segments=24)
  Porta_B8.subtract(Buraco_B8)
  Porta_B9 = circle(normal=Z, centre=(14.45605905mm, 14.55294169mm, -1.5mm), radius=1.515mm, segments=24)
  Buraco_B9 = circle(normal=Z, centre=(14.45605905mm, 14.55294169mm, -1.5mm), radius=0.45975mm, segments=24)
  Porta_B9.subtract(Buraco_B9)
  Porta_B10 = circle(normal=Z, centre=(14.45605905mm, 23.94705831mm, -1.5mm), radius=1.515mm, segments=24)
  Buraco_B10 = circle(normal=Z, centre=(14.45605905mm, 23.94705831mm, -1.5mm), radius=0.45975mm, segments=24)
  Porta_B10.subtract(Buraco_B10)
  RadiatingSurface [vacuum] = region(absolute_offset=19.646365mm on all sides)
boundaries and excitations:
  Cobre_35um: Finite Conductivity Objects=[GND, Estrela_B, Estrela_A, Anel_A_IN, Anel_A1..Anel_A10, Anel_B_IN, Anel_B1..Anel_B10] UseMaterial Material=copper Thickness=0.035mm Roughness=0.5um IsInternal
  Open1: Radiation Objects=RadiatingSurface
  A_IN: Lumped Port Objects=Porta_A_IN LumpedPortType=Modal Modes{Mode1{IntLine{(0.45975, -19.25, -1.5) -> (1.515, -19.25, -1.5)} CharImp=Zpi RenormImp=50ohm}} Impedance=50ohm
  A1: Lumped Port Objects=Porta_A1 LumpedPortType=Modal Modes{Mode1{IntLine{(-13.99630905, -23.94705831, -1.5) -> (-12.94105905, -23.94705831, -1.5)} CharImp=Zpi RenormImp=50ohm}} Impedance=50ohm
  A2: Lumped Port Objects=Porta_A2 LumpedPortType=Modal Modes{Mode1{IntLine{(-13.99630905, -14.55294169, -1.5) -> (-12.94105905, -14.55294169, -1.5)} CharImp=Zpi RenormImp=50ohm}} Impedance=50ohm
  A3: Lumped Port Objects=Porta_A3 LumpedPortType=Modal Modes{Mode1{IntLine{(-8.47458583, -31.54705831, -1.5) -> (-7.41933583, -31.54705831, -1.5)} CharImp=Zpi RenormImp=50ohm}} Impedance=50ohm
  A4: Lumped Port Objects=Porta_A4 LumpedPortType=Modal Modes{Mode1{IntLine{(-8.47458583, -6.95294169, -1.5) -> (-7.41933583, -6.95294169, -1.5)} CharImp=Zpi RenormImp=50ohm}} Impedance=50ohm
  A5: Lumped Port Objects=Porta_A5 LumpedPortType=Modal Modes{Mode1{IntLine{(0.45975, -34.45, -1.5) -> (1.515, -34.45, -1.5)} CharImp=Zpi RenormImp=50ohm}} Impedance=50ohm
  A6: Lumped Port Objects=Porta_A6 LumpedPortType=Modal Modes{Mode1{IntLine{(0.45975, -4.05, -1.5) -> (1.515, -4.05, -1.5)} CharImp=Zpi RenormImp=50ohm}} Impedance=50ohm
  A7: Lumped Port Objects=Porta_A7 LumpedPortType=Modal Modes{Mode1{IntLine{(9.39408583, -31.54705831, -1.5) -> (10.44933583, -31.54705831, -1.5)} CharImp=Zpi RenormImp=50ohm}} Impedance=50ohm
  A8: Lumped Port Objects=Porta_A8 LumpedPortType=Modal Modes{Mode1{IntLine{(9.39408583, -6.95294169, -1.5) -> (10.44933583, -6.95294169, -1.5)} CharImp=Zpi RenormImp=50ohm}} Impedance=50ohm
  A9: Lumped Port Objects=Porta_A9 LumpedPortType=Modal Modes{Mode1{IntLine{(14.91580905, -23.94705831, -1.5) -> (15.97105905, -23.94705831, -1.5)} CharImp=Zpi RenormImp=50ohm}} Impedance=50ohm
  A10: Lumped Port Objects=Porta_A10 LumpedPortType=Modal Modes{Mode1{IntLine{(14.91580905, -14.55294169, -1.5) -> (15.97105905, -14.55294169, -1.5)} CharImp=Zpi RenormImp=50ohm}} Impedance=50ohm
  B_IN: Lumped Port Objects=Porta_B_IN LumpedPortType=Modal Modes{Mode1{IntLine{(0.45975, 19.25, -1.5) -> (1.515, 19.25, -1.5)} CharImp=Zpi RenormImp=50ohm}} Impedance=50ohm
  B1: Lumped Port Objects=Porta_B1 LumpedPortType=Modal Modes{Mode1{IntLine{(-13.99630905, 14.55294169, -1.5) -> (-12.94105905, 14.55294169, -1.5)} CharImp=Zpi RenormImp=50ohm}} Impedance=50ohm
  B2: Lumped Port Objects=Porta_B2 LumpedPortType=Modal Modes{Mode1{IntLine{(-13.99630905, 23.94705831, -1.5) -> (-12.94105905, 23.94705831, -1.5)} CharImp=Zpi RenormImp=50ohm}} Impedance=50ohm
  B3: Lumped Port Objects=Porta_B3 LumpedPortType=Modal Modes{Mode1{IntLine{(-8.47458583, 6.95294169, -1.5) -> (-7.41933583, 6.95294169, -1.5)} CharImp=Zpi RenormImp=50ohm}} Impedance=50ohm
  B4: Lumped Port Objects=Porta_B4 LumpedPortType=Modal Modes{Mode1{IntLine{(-8.47458583, 31.54705831, -1.5) -> (-7.41933583, 31.54705831, -1.5)} CharImp=Zpi RenormImp=50ohm}} Impedance=50ohm
  B5: Lumped Port Objects=Porta_B5 LumpedPortType=Modal Modes{Mode1{IntLine{(0.45975, 4.05, -1.5) -> (1.515, 4.05, -1.5)} CharImp=Zpi RenormImp=50ohm}} Impedance=50ohm
  B6: Lumped Port Objects=Porta_B6 LumpedPortType=Modal Modes{Mode1{IntLine{(0.45975, 34.45, -1.5) -> (1.515, 34.45, -1.5)} CharImp=Zpi RenormImp=50ohm}} Impedance=50ohm
  B7: Lumped Port Objects=Porta_B7 LumpedPortType=Modal Modes{Mode1{IntLine{(9.39408583, 6.95294169, -1.5) -> (10.44933583, 6.95294169, -1.5)} CharImp=Zpi RenormImp=50ohm}} Impedance=50ohm
  B8: Lumped Port Objects=Porta_B8 LumpedPortType=Modal Modes{Mode1{IntLine{(9.39408583, 31.54705831, -1.5) -> (10.44933583, 31.54705831, -1.5)} CharImp=Zpi RenormImp=50ohm}} Impedance=50ohm
  B9: Lumped Port Objects=Porta_B9 LumpedPortType=Modal Modes{Mode1{IntLine{(14.91580905, 14.55294169, -1.5) -> (15.97105905, 14.55294169, -1.5)} CharImp=Zpi RenormImp=50ohm}} Impedance=50ohm
  B10: Lumped Port Objects=Porta_B10 LumpedPortType=Modal Modes{Mode1{IntLine{(14.91580905, 23.94705831, -1.5) -> (15.97105905, 23.94705831, -1.5)} CharImp=Zpi RenormImp=50ohm}} Impedance=50ohm
setups:
  Divisor: HfssDriven Frequency=5.17GHz MaxDeltaS=0.015 MaximumPasses=14 MinimumPasses=2 MinimumConvergedPasses=1 PercentRefinement=28 BasisOrder=1 PortAccuracy=2 DrivenSolverType="Direct Solver"
    sweep Banda: 5090MHz to 5250MHz step 10MHz; Type=Discrete
source amplitudes:
  A_IN:1: 1W 0deg
  A1:1, A2:1, A3:1, A4:1, A5:1, A6:1, A7:1, A8:1, A9:1, A10:1, B_IN:1, B1:1, B2:1, B3:1, B4:1, B5:1, B6:1, B7:1, B8:1, B9:1, B10:1: 0W 0deg
radiation setups:
  3D: Infinite Sphere Theta=0deg..180deg step 2deg Phi=-180deg..180deg step 2deg
  Elevation: Infinite Sphere Theta=-180deg..180deg step 1deg Phi=0deg..90deg step 90deg
  Azimuth: Infinite Sphere Theta=90deg..90deg step 0deg Phi=-180deg..180deg step 1deg
