# Ansys Electronics Desktop project, version 2024.2
materials:
  vacuum: permittivity=1
  PA_nom: permittivity=3.3 dielectric_loss_tangent=0.02
  PTFE_cabo: permittivity=2.0363635 dielectric_loss_tangent=0.00027683055
  ZYF300: permittivity=2.94 dielectric_loss_tangent=0.0016
  Silicone_nom: permittivity=2.77 dielectric_loss_tangent=0.02
  POM_nom: permittivity=3.4 dielectric_loss_tangent=0.01
  RO4350B_R01: permittivity=3.66 dielectric_loss_tangent=0.0037
  PE_nom: permittivity=2.3 dielectric_loss_tangent=0.001
  AL5052: conductivity=20000000
  aco_nom: conductivity=1400000
  SAC305: conductivity=7575758
  latao_nom: conductivity=16000000
  copper: permeability=0.999991 conductivity=58000000

design Painel_montado (HFSS, HFSS Hybrid Modal Network, model units mm)
geometry:
  AL5052 [AL5052] = imported_body(D:\dev\EMBRAER\P1H\R03_Estudo/painel_C\cad\AL5052.step)
  Nylon_pcb_13, Nylon_pcb_13_1, Nylon_pcb_12, Nylon_pcb_12_1, Nylon_pcb_11, Nylon_pcb_11_1, Nylon_pcb_10, Nylon_pcb_10_1, Nylon_pcb_09, Nylon_pcb_09_1, Nylon_pcb_08, Nylon_pcb_08_1, Nylon_pcb_07, Nylon_pcb_07_1, Nylon_pcb_06, Nylon_pcb_06_1, Nylon_pcb_05, Nylon_pcb_05_1, Nylon_pcb_04, Nylon_pcb_04_1, Nylon_pcb_03, Nylon_pcb_03_1, Nylon_pcb_02, Nylon_pcb_02_1, Nylon_pcb_01, Nylon_pcb_01_1, Nylon_pcb_00, Nylon_pcb_00_1 [PA_nom] = imported_body(D:\dev\EMBRAER\P1H\R03_Estudo/painel_C\cad\PA_nom.step)
  Termorretratil_N_B, Termorretratil_N_A [PE_nom] = imported_body(D:\dev\EMBRAER\P1H\R03_Estudo/painel_C\cad\PE_nom.step)
  Espacador_13, Espacador_12, Espacador_11, Espacador_10, Espacador_09, Espacador_08, Espacador_07, Espacador_06, Espacador_05, Espacador_04, Espacador_03, Espacador_02, Espacador_01, Espacador_00, Batente_7, Batente_6, Berco_5, Berco_4, Berco_3, Berco_2, Berco_1 [POM_nom] = imported_body(D:\dev\EMBRAER\P1H\R03_Estudo/painel_C\cad\POM_nom.step)
  Isol_IN_B, Isol_IN_A, Isol_E10_B, Isol_E10_A, Isol_E09_B, Isol_E09_A, Isol_E08_B, Isol_E08_A, Isol_E07_B, Isol_E07_A, Isol_E06_B, Isol_E06_A, Isol_E05_B, Isol_E05_A, Isol_E04_B, Isol_E04_A, Isol_E03_B, Isol_E03_A, Isol_E02_B, Isol_E02_A, Isol_E01_B, Isol_E01_A, N_isol_B, N_isol_A [PTFE_cabo] = imported_body(D:\dev\EMBRAER\P1H\R03_Estudo/painel_C\cad\PTFE_cabo.step)
  RO4350B_R01 [RO4350B_R01] = imported_body(D:\dev\EMBRAER\P1H\R03_Estudo/painel_C\cad\RO4350B_R01.step)
  Solda_B10, Solda_B9, Solda_B8, Solda_B7, Solda_B6, Solda_A10, Solda_A9, Solda_A8, Solda_A7, Solda_A6, Solda_B5, Solda_B4, Solda_B3, Solda_B2, Solda_B1, Solda_A5, Solda_A4, Solda_A3, Solda_A2, Solda_A1 [SAC305] = imported_body(D:\dev\EMBRAER\P1H\R03_Estudo/painel_C\cad\SAC305.step)
  Junta_N_B, Junta_N_A, Passa_cabos_10, Passa_cabos_09, Passa_cabos_08, Passa_cabos_07, Passa_cabos_06, Passa_cabos_05, Passa_cabos_04, Passa_cabos_03, Passa_cabos_02, Passa_cabos_01 [Silicone_nom] = imported_body(D:\dev\EMBRAER\P1H\R03_Estudo/painel_C\cad\Silicone_nom.step)
  Laminado_Superior, Laminado_Inferior [ZYF300] = imported_body(D:\dev\EMBRAER\P1H\R03_Estudo/painel_C\cad\ZYF300.step)
  Par_fronte_13, Par_fronte_13_1, Par_fronte_12, Par_fronte_12_1, Par_fronte_11, Par_fronte_11_1, Par_fronte_10, Par_fronte_10_1, Par_fronte_09, Par_fronte_09_1, Par_fronte_08, Par_fronte_08_1, Par_fronte_07, Par_fronte_07_1, Par_fronte_06, Par_fronte_06_1, Par_fronte_05, Par_fronte_05_1, Par_fronte_04, Par_fronte_04_1, Par_fronte_03, Par_fronte_03_1, Par_fronte_02, Par_fronte_02_1, Par_fronte_01, Par_fronte_01_1, Par_fronte_00, Par_fronte_00_1, Par_6_1, Par_6_1_1, Par_6_0, Par_6_0_1, Par_5_1, Par_5_1_1, Par_5_0, Par_5_0_1, Par_4_1, Par_4_1_1, Par_4_0, Par_4_0_1, Par_3_1, Par_3_1_1, Par_3_0, Par_3_0_1, Par_2_1, Par_2_1_1, Par_2_0, Par_2_0_1, Par_1_1, Par_1_1_1, Par_1_0, Par_1_0_1, Par_0_1, Par_0_1_1, Par_0_0, Par_0_0_1 [aco_nom] = imported_body(D:\dev\EMBRAER\P1H\R03_Estudo/painel_C\cad\aco_nom.step)
  Lancamento_B, Lancamento_A, Capa_E10_B, Sinal_E10_B, Capa_E10_A, Sinal_E10_A, Capa_E09_B, Sinal_E09_B, Capa_E09_A, Sinal_E09_A, Capa_E08_B, Sinal_E08_B, Capa_E08_A, Sinal_E08_A, Capa_E07_B, Sinal_E07_B, Capa_E07_A, Sinal_E07_A, Capa_E06_B, Sinal_E06_B, Capa_E06_A, Sinal_E06_A, Capa_E05_B, Sinal_E05_B, Capa_E05_A, Sinal_E05_A, Capa_E04_B, Sinal_E04_B, Capa_E04_A, Sinal_E04_A, Capa_E03_B, Sinal_E03_B, Capa_E03_A, Sinal_E03_A, Capa_E02_B, Sinal_E02_B, Capa_E02_A, Sinal_E02_A, Capa_E01_B, Sinal_E01_B, Capa_E01_A, Sinal_E01_A, Emenda_massa001, Emenda_massa, Emenda_sinal001, Emenda_sinal, Via09_1, Via09_0, Via08_1, Via08_0, Via07_1, Via07_0, Via06_1, Via06_0, Via05_1, Via05_0, Via04_1, Via04_0, Via03_1, Via03_0, Via02_1, Via02_0, Via01_1, Via01_0, Via00_1, Via00_0 [copper] = imported_body(D:\dev\EMBRAER\P1H\R03_Estudo/painel_C\cad\copper.step)
  Rede_Superior001, Rede_Superior, GND_Superior, Pad_B10, Pad_B9, Pad_B8, Pad_B7, Pad_B6, Pad_A10, Pad_A9, Pad_A8, Pad_A7, Pad_A6, Rede_Inferior001, Rede_Inferior, GND_Inferior, Pad_B5, Pad_B4, Pad_B3, Pad_B2, Pad_B1, Pad_B_IN, Pad_A5, Pad_A4, Pad_A3, Pad_A2, Pad_A1, Pad_A_IN, Ant10_PadB1, Ant10_PadB0, Ant10_Feed_B_Inner, Ant10_Feed_B_Outer, Ant10_Feed_A, Ant10_Crossover_Bridge, Ant10_Ring_Q4, Ant10_Ring_Q3, Ant10_Ring_Q2, Ant10_Ring_Q1, Ant09_PadB1, Ant09_PadB0, Ant09_Feed_B_Inner, Ant09_Feed_B_Outer, Ant09_Feed_A, Ant09_Crossover_Bridge, Ant09_Ring_Q4, Ant09_Ring_Q3, Ant09_Ring_Q2, Ant09_Ring_Q1, Ant08_PadB1, Ant08_PadB0, Ant08_Feed_B_Inner, Ant08_Feed_B_Outer, Ant08_Feed_A, Ant08_Crossover_Bridge, Ant08_Ring_Q4, Ant08_Ring_Q3, Ant08_Ring_Q2, Ant08_Ring_Q1, Ant07_PadB1, Ant07_PadB0, Ant07_Feed_B_Inner, Ant07_Feed_B_Outer, Ant07_Feed_A, Ant07_Crossover_Bridge, Ant07_Ring_Q4, Ant07_Ring_Q3, Ant07_Ring_Q2, Ant07_Ring_Q1, Ant06_PadB1, Ant06_PadB0, Ant06_Feed_B_Inner, Ant06_Feed_B_Outer, Ant06_Feed_A, Ant06_Crossover_Bridge, Ant06_Ring_Q4, Ant06_Ring_Q3, Ant06_Ring_Q2, Ant06_Ring_Q1, Ant05_PadB1, Ant05_PadB0, Ant05_Feed_B_Inner, Ant05_Feed_B_Outer, Ant05_Feed_A, Ant05_Crossover_Bridge, Ant05_Ring_Q4, Ant05_Ring_Q3, Ant05_Ring_Q2, Ant05_Ring_Q1, Ant04_PadB1, Ant04_PadB0, Ant04_Feed_B_Inner, Ant04_Feed_B_Outer, Ant04_Feed_A, Ant04_Crossover_Bridge, Ant04_Ring_Q4, Ant04_Ring_Q3, Ant04_Ring_Q2, Ant04_Ring_Q1, Ant03_PadB1, Ant03_PadB0, Ant03_Feed_B_Inner, Ant03_Feed_B_Outer, Ant03_Feed_A, Ant03_Crossover_Bridge, Ant03_Ring_Q4, Ant03_Ring_Q3, Ant03_Ring_Q2, Ant03_Ring_Q1, Ant02_PadB1, Ant02_PadB0, Ant02_Feed_B_Inner, Ant02_Feed_B_Outer, Ant02_Feed_A, Ant02_Crossover_Bridge, Ant02_Ring_Q4, Ant02_Ring_Q3, Ant02_Ring_Q2, Ant02_Ring_Q1, Ant01_PadB1, Ant01_PadB0, Ant01_Feed_B_Inner, Ant01_Feed_B_Outer, Ant01_Feed_A, Ant01_Crossover_Bridge, Ant01_Ring_Q4, Ant01_Ring_Q3, Ant01_Ring_Q2, Ant01_Ring_Q1 = imported_body(D:\dev\EMBRAER\P1H\R03_Estudo/painel_C\cad\folha_cu.step)
  N_pino_B, N_corpo_B, N_pino_A, N_corpo_A [latao_nom] = imported_body(D:\dev\EMBRAER\P1H\R03_Estudo/painel_C\cad\latao_nom.step)
  Plano_N_A = circle(normal=X, centre=(-288mm, -19.25mm, -31mm), radius=3.5mm)
  Miolo_A = circle(normal=X, centre=(-288mm, -19.25mm, -31mm), radius=1.5217391mm)
  Plano_N_A.subtract(Miolo_A)
  Plano_N_B = circle(normal=X, centre=(-288mm, 19.25mm, -31mm), radius=3.5mm)
  Miolo_B = circle(normal=X, centre=(-288mm, 19.25mm, -31mm), radius=1.5217391mm)
  Plano_N_B.subtract(Miolo_B)
  RadiatingSurface [vacuum] = region(absolute_offset=19.646365mm on all sides)
boundaries and excitations:
  Metais_impressos_35um: Finite Conductivity Objects=[Ant01_Crossover_Bridge, Ant01_Feed_A, Ant01_Feed_B_Inner, Ant01_Feed_B_Outer, Ant01_PadB0, Ant01_PadB1, Ant01_Ring_Q1..Ant01_Ring_Q4, Ant02_Crossover_Bridge, Ant02_Feed_A, Ant02_Feed_B_Inner, Ant02_Feed_B_Outer, Ant02_PadB0, Ant02_PadB1, Ant02_Ring_Q1..Ant02_Ring_Q4, Ant03_Crossover_Bridge, Ant03_Feed_A, Ant03_Feed_B_Inner, Ant03_Feed_B_Outer, Ant03_PadB0, Ant03_PadB1, Ant03_Ring_Q1..Ant03_Ring_Q4, Ant04_Crossover_Bridge, Ant04_Feed_A, Ant04_Feed_B_Inner, Ant04_Feed_B_Outer, Ant04_PadB0, Ant04_PadB1, Ant04_Ring_Q1..Ant04_Ring_Q4, Ant05_Crossover_Bridge, Ant05_Feed_A, Ant05_Feed_B_Inner, Ant05_Feed_B_Outer, Ant05_PadB0, Ant05_PadB1, Ant05_Ring_Q1..Ant05_Ring_Q4, Ant06_Crossover_Bridge, Ant06_Feed_A, Ant06_Feed_B_Inner, Ant06_Feed_B_Outer, Ant06_PadB0, Ant06_PadB1, Ant06_Ring_Q1..Ant06_Ring_Q4, Ant07_Crossover_Bridge, Ant07_Feed_A, Ant07_Feed_B_Inner, Ant07_Feed_B_Outer, Ant07_PadB0, Ant07_PadB1, Ant07_Ring_Q1..Ant07_Ring_Q4, Ant08_Crossover_Bridge, Ant08_Feed_A, Ant08_Feed_B_Inner, Ant08_Feed_B_Outer, Ant08_PadB0, Ant08_PadB1, Ant08_Ring_Q1..Ant08_Ring_Q4, Ant09_Crossover_Bridge, Ant09_Feed_A, Ant09_Feed_B_Inner, Ant09_Feed_B_Outer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] UseMaterial Material=copper Thickness=0.035mm Roughness=0.5um IsInternal
  Open1: Radiation Objects=RadiatingSurface
  N_A: Lumped Port Objects=Plano_N_A LumpedPortType=Modal Modes{Mode1{IntLine{(-288, -17.728261, -31) -> (-288, -15.75, -31)} CharImp=Zpi RenormImp=50ohm}} Impedance=50ohm
  N_B: Lumped Port Objects=Plano_N_B LumpedPortType=Modal Modes{Mode1{IntLine{(-288, 20.771739, -31) -> (-288, 22.75, -31)} CharImp=Zpi RenormImp=50ohm}} Impedance=50ohm
mesh:
  initial mesh: GlobalSurfApproximation{CurvedSurfaceApproxChoice=ManualSettings SurfDev=0.035mm NormalDev=25deg AspectRatio=25} GlobalCurvilinear{Apply} GlobalModelRes{DefeatureLength=0.002mm} MeshMethod=AnsoftTAU UseFlexMeshingForTAUvolumeMesh
setups:
  Banda: HfssDriven Frequency=5.17GHz MaxDeltaS=0.015 MaximumPasses=12 MinimumPasses=3 MinimumConvergedPasses=2 PercentRefinement=23 BasisOrder=-1 PortAccuracy=2 DrivenSolverType="Direct Solver"
source amplitudes:
  N_A:1, N_B:1: 0.5W 0deg
radiation setups:
  3D: Infinite Sphere Theta=0deg..180deg step 2deg Phi=-180deg..180deg step 2deg
  Elevation: Infinite Sphere Theta=-180deg..180deg step 1deg Phi=0deg..90deg step 90deg
  Azimuth: Infinite Sphere Theta=90deg..90deg step 0deg Phi=-180deg..180deg step 1deg
  HV: Infinite Sphere Theta=-180deg..180deg step 0.25deg Phi=0deg..90deg step 90deg
