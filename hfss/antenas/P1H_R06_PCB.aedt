# Ansys Electronics Desktop project, version 2024.2
materials:
  vacuum: permittivity=1
  POM_nom: permittivity=3.4 dielectric_loss_tangent=0.01
  RO4350B_R01: permittivity=3.66 dielectric_loss_tangent=0.0037
  AL5052: conductivity=20000000
  aco_nom: conductivity=1400000
  SAC305: conductivity=7575758
  copper: permeability=0.999991 conductivity=58000000
  NiP_vol_nominal: permeability=1 conductivity=1500000
  Ouro_vol_nominal: permeability=1 conductivity=41000000
  Cobre_vol_Groiss: permeability=1 conductivity=28688604

design PCB_sem_cabos (HFSS, HFSS Hybrid Modal Network, model units mm)
geometry:
  AL5052 [AL5052] = imported_body(D:\dev\EMBRAER\P1H\R06_sem_cabos\antena\cad\AL5052.step)
  Batente_7, Batente_6, Berco_5, Berco_4, Berco_3, Berco_2, Berco_1 [POM_nom] = imported_body(D:\dev\EMBRAER\P1H\R06_sem_cabos\antena\cad\POM_nom.step)
  RO4350B_R01 [RO4350B_R01] = imported_body(D:\dev\EMBRAER\P1H\R06_sem_cabos\antena\cad\RO4350B_R01.step)
  Solda_terminal_39, Solda_terminal_38, Solda_terminal_37, Solda_terminal_36, Solda_terminal_35, Solda_terminal_34, Solda_terminal_33, Solda_terminal_32, Solda_terminal_31, Solda_terminal_30, Solda_terminal_29, Solda_terminal_28, Solda_terminal_27, Solda_terminal_26, Solda_terminal_25, Solda_terminal_24, Solda_terminal_23, Solda_terminal_22, Solda_terminal_21, Solda_terminal_20, Solda_terminal_19, Solda_terminal_18, Solda_terminal_17, Solda_terminal_16, Solda_terminal_15, Solda_terminal_14, Solda_terminal_13, Solda_terminal_12, Solda_terminal_11, Solda_terminal_10, Solda_terminal_09, Solda_terminal_08, Solda_terminal_07, Solda_terminal_06, Solda_terminal_05, Solda_terminal_04, Solda_terminal_03, Solda_terminal_02, Solda_terminal_01, Solda_terminal_00 [SAC305] = imported_body(D:\dev\EMBRAER\P1H\R06_sem_cabos\antena\cad\SAC305.step)
  Par_6_003, Par_6_001, Par_5_003, Par_5_001, Par_4_003, Par_4_001, Par_3_003, Par_3_001, Par_2_003, Par_2_001, Par_1_003, Par_1_001, Par_0_003, Par_0_001 [aco_nom] = imported_body(D:\dev\EMBRAER\P1H\R06_sem_cabos\antena\cad\aco_nom.step)
  Capa_SUP_B3, Sinal_SUP_B3, Capa_SUP_A3, Sinal_SUP_A3, Capa_SUP_B4, Sinal_SUP_B4, Capa_SUP_B2, Sinal_SUP_B2, Capa_SUP_A4, Sinal_SUP_A4, Capa_SUP_A2, Sinal_SUP_A2, Capa_SUP_B5, Sinal_SUP_B5, Capa_SUP_B1, Sinal_SUP_B1, Capa_SUP_A5, Sinal_SUP_A5, Capa_SUP_A1, Sinal_SUP_A1, Capa_INF_B3, Sinal_INF_B3, Capa_INF_A3, Sinal_INF_A3, Capa_INF_B4, Sinal_INF_B4, Capa_INF_B2, Sinal_INF_B2, Capa_INF_A4, Sinal_INF_A4, Capa_INF_A2, Sinal_INF_A2, Capa_INF_B5, Sinal_INF_B5, Capa_INF_B1, Sinal_INF_B1, Capa_INF_A5, Sinal_INF_A5, Capa_INF_A1, Sinal_INF_A1, Via09_1, Via09_0, Via08_1, Via08_0, Via07_1, Via07_0, Via06_1, Via06_0, Via05_1, Via05_0, Via04_1, Via04_0, Via03_1, Via03_0, Via02_1, Via02_0, Via01_1, Via01_0, Via00_1, Via00_0 [copper] = imported_body(D:\dev\EMBRAER\P1H\R06_sem_cabos\antena\cad\copper.step)
  Ant10_Feed_B_Inner_Cu1, Ant10_Feed_B_Inner_Cu0, Ant10_Feed_B_Outer, Ant10_Feed_A_Cu1, Ant10_Feed_A_Cu0, Ant10_Crossover_Bridge, Ant10_Ring_Q4, Ant10_Ring_Q3, Ant10_Ring_Q2, Ant10_Ring_Q1, Ant09_Feed_B_Inner_Cu1, Ant09_Feed_B_Inner_Cu0, Ant09_Feed_B_Outer, Ant09_Feed_A_Cu1, Ant09_Feed_A_Cu0, Ant09_Crossover_Bridge, Ant09_Ring_Q4, Ant09_Ring_Q3, Ant09_Ring_Q2, Ant09_Ring_Q1, Ant08_Feed_B_Inner_Cu1, Ant08_Feed_B_Inner_Cu0, Ant08_Feed_B_Outer, Ant08_Feed_A_Cu1, Ant08_Feed_A_Cu0, Ant08_Crossover_Bridge, Ant08_Ring_Q4, Ant08_Ring_Q3, Ant08_Ring_Q2, Ant08_Ring_Q1, Ant07_Feed_B_Inner_Cu1, Ant07_Feed_B_Inner_Cu0, Ant07_Feed_B_Outer, Ant07_Feed_A_Cu1, Ant07_Feed_A_Cu0, Ant07_Crossover_Bridge, Ant07_Ring_Q4, Ant07_Ring_Q3, Ant07_Ring_Q2, Ant07_Ring_Q1, Ant06_Feed_B_Inner_Cu1, Ant06_Feed_B_Inner_Cu0, Ant06_Feed_B_Outer, Ant06_Feed_A_Cu1, Ant06_Feed_A_Cu0, Ant06_Crossover_Bridge, Ant06_Ring_Q4, Ant06_Ring_Q3, Ant06_Ring_Q2, Ant06_Ring_Q1, Ant05_Feed_B_Inner_Cu1, Ant05_Feed_B_Inner_Cu0, Ant05_Feed_B_Outer, Ant05_Feed_A_Cu1, Ant05_Feed_A_Cu0, Ant05_Crossover_Bridge, Ant05_Ring_Q4, Ant05_Ring_Q3, Ant05_Ring_Q2, Ant05_Ring_Q1, Ant04_Feed_B_Inner_Cu1, Ant04_Feed_B_Inner_Cu0, Ant04_Feed_B_Outer, Ant04_Feed_A_Cu1, Ant04_Feed_A_Cu0, Ant04_Crossover_Bridge, Ant04_Ring_Q4, Ant04_Ring_Q3, Ant04_Ring_Q2, Ant04_Ring_Q1, Ant03_Feed_B_Inner_Cu1, Ant03_Feed_B_Inner_Cu0, Ant03_Feed_B_Outer, Ant03_Feed_A_Cu1, Ant03_Feed_A_Cu0, Ant03_Crossover_Bridge, Ant03_Ring_Q4, Ant03_Ring_Q3, Ant03_Ring_Q2, Ant03_Ring_Q1, Ant02_Feed_B_Inner_Cu1, Ant02_Feed_B_Inner_Cu0, Ant02_Feed_B_Outer, Ant02_Feed_A_Cu1, Ant02_Feed_A_Cu0, Ant02_Crossover_Bridge, Ant02_Ring_Q4, Ant02_Ring_Q3, Ant02_Ring_Q2, Ant02_Ring_Q1, Ant01_Feed_B_Inner_Cu1, Ant01_Feed_B_Inner_Cu0, Ant01_Feed_B_Outer, Ant01_Feed_A_Cu1, Ant01_Feed_A_Cu0, Ant01_Crossover_Bridge, Ant01_Ring_Q4, Ant01_Ring_Q3, Ant01_Ring_Q2, Ant01_Ring_Q1 [Cobre_vol_Groiss] = imported_body(D:\dev\EMBRAER\P1H\R06_sem_cabos\antena\cad\folha_cu.step)
  E01_A_externo = circle(normal=Z, centre=(-234.19083mm, -2.5091684mm, 16.575mm), radius=0.834856mm)
  E01_A_interno = circle(normal=Z, centre=(-234.19083mm, -2.5091684mm, 16.575mm), radius=0.6mm)
  E01_A_externo.subtract(E01_A_interno)
  E01_B_externo = circle(normal=Z, centre=(-234.19083mm, 2.5091684mm, 16.575mm), radius=0.834856mm)
  E01_B_interno = circle(normal=Z, centre=(-234.19083mm, 2.5091684mm, 16.575mm), radius=0.6mm)
  E01_B_externo.subtract(E01_B_interno)
  E02_A_externo = circle(normal=Z, centre=(-181.59083mm, -2.5091684mm, 16.575mm), radius=0.834856mm)
  E02_A_interno = circle(normal=Z, centre=(-181.59083mm, -2.5091684mm, 16.575mm), radius=0.6mm)
  E02_A_externo.subtract(E02_A_interno)
  E02_B_externo = circle(normal=Z, centre=(-181.59083mm, 2.5091684mm, 16.575mm), radius=0.834856mm)
  E02_B_interno = circle(normal=Z, centre=(-181.59083mm, 2.5091684mm, 16.575mm), radius=0.6mm)
  E02_B_externo.subtract(E02_B_interno)
  E03_A_externo = circle(normal=Z, centre=(-128.99083mm, -2.5091684mm, 16.575mm), radius=0.834856mm)
  E03_A_interno = circle(normal=Z, centre=(-128.99083mm, -2.5091684mm, 16.575mm), radius=0.6mm)
  E03_A_externo.subtract(E03_A_interno)
  E03_B_externo = circle(normal=Z, centre=(-128.99083mm, 2.5091684mm, 16.575mm), radius=0.834856mm)
  E03_B_interno = circle(normal=Z, centre=(-128.99083mm, 2.5091684mm, 16.575mm), radius=0.6mm)
  E03_B_externo.subtract(E03_B_interno)
  E04_A_externo = circle(normal=Z, centre=(-76.390832mm, -2.5091684mm, 16.575mm), radius=0.834856mm)
  E04_A_interno = circle(normal=Z, centre=(-76.390832mm, -2.5091684mm, 16.575mm), radius=0.6mm)
  E04_A_externo.subtract(E04_A_interno)
  E04_B_externo = circle(normal=Z, centre=(-76.390832mm, 2.5091684mm, 16.575mm), radius=0.834856mm)
  E04_B_interno = circle(normal=Z, centre=(-76.390832mm, 2.5091684mm, 16.575mm), radius=0.6mm)
  E04_B_externo.subtract(E04_B_interno)
  E05_A_externo = circle(normal=Z, centre=(-23.790832mm, -2.5091684mm, 16.575mm), radius=0.834856mm)
  E05_A_interno = circle(normal=Z, centre=(-23.790832mm, -2.5091684mm, 16.575mm), radius=0.6mm)
  E05_A_externo.subtract(E05_A_interno)
  E05_B_externo = circle(normal=Z, centre=(-23.790832mm, 2.5091684mm, 16.575mm), radius=0.834856mm)
  E05_B_interno = circle(normal=Z, centre=(-23.790832mm, 2.5091684mm, 16.575mm), radius=0.6mm)
  E05_B_externo.subtract(E05_B_interno)
  E06_A_externo = circle(normal=Z, centre=(28.809168mm, -2.5091684mm, 16.575mm), radius=0.834856mm)
  E06_A_interno = circle(normal=Z, centre=(28.809168mm, -2.5091684mm, 16.575mm), radius=0.6mm)
  E06_A_externo.subtract(E06_A_interno)
  E06_B_externo = circle(normal=Z, centre=(28.809168mm, 2.5091684mm, 16.575mm), radius=0.834856mm)
  E06_B_interno = circle(normal=Z, centre=(28.809168mm, 2.5091684mm, 16.575mm), radius=0.6mm)
  E06_B_externo.subtract(E06_B_interno)
  E07_A_externo = circle(normal=Z, centre=(81.409168mm, -2.5091684mm, 16.575mm), radius=0.834856mm)
  E07_A_interno = circle(normal=Z, centre=(81.409168mm, -2.5091684mm, 16.575mm), radius=0.6mm)
  E07_A_externo.subtract(E07_A_interno)
  E07_B_externo = circle(normal=Z, centre=(81.409168mm, 2.5091684mm, 16.575mm), radius=0.834856mm)
  E07_B_interno = circle(normal=Z, centre=(81.409168mm, 2.5091684mm, 16.575mm), radius=0.6mm)
  E07_B_externo.subtract(E07_B_interno)
  E08_A_externo = circle(normal=Z, centre=(134.00917mm, -2.5091684mm, 16.575mm), radius=0.834856mm)
  E08_A_interno = circle(normal=Z, centre=(134.00917mm, -2.5091684mm, 16.575mm), radius=0.6mm)
  E08_A_externo.subtract(E08_A_interno)
  E08_B_externo = circle(normal=Z, centre=(134.00917mm, 2.5091684mm, 16.575mm), radius=0.834856mm)
  E08_B_interno = circle(normal=Z, centre=(134.00917mm, 2.5091684mm, 16.575mm), radius=0.6mm)
  E08_B_externo.subtract(E08_B_interno)
  E09_A_externo = circle(normal=Z, centre=(186.60917mm, -2.5091684mm, 16.575mm), radius=0.834856mm)
  E09_A_interno = circle(normal=Z, centre=(186.60917mm, -2.5091684mm, 16.575mm), radius=0.6mm)
  E09_A_externo.subtract(E09_A_interno)
  E09_B_externo = circle(normal=Z, centre=(186.60917mm, 2.5091684mm, 16.575mm), radius=0.834856mm)
  E09_B_interno = circle(normal=Z, centre=(186.60917mm, 2.5091684mm, 16.575mm), radius=0.6mm)
  E09_B_externo.subtract(E09_B_interno)
  E10_A_externo = circle(normal=Z, centre=(239.20917mm, -2.5091684mm, 16.575mm), radius=0.834856mm)
  E10_A_interno = circle(normal=Z, centre=(239.20917mm, -2.5091684mm, 16.575mm), radius=0.6mm)
  E10_A_externo.subtract(E10_A_interno)
  E10_B_externo = circle(normal=Z, centre=(239.20917mm, 2.5091684mm, 16.575mm), radius=0.834856mm)
  E10_B_interno = circle(normal=Z, centre=(239.20917mm, 2.5091684mm, 16.575mm), radius=0.6mm)
  E10_B_externo.subtract(E10_B_interno)
  RadiatingSurface [vacuum] = region(absolute_offset=19.646365mm on all sides)
boundaries and excitations:
  ENIG_faces_expostas: Layered Impedance Faces=Ant01_Crossover_Bridge.face(at (-237.047, 0.347013, 16.5925), at (-235.686, 1.01434, 16.5925), at (-236.353, -0.347013, 16.5925), at (-237.714, -1.01434, 16.5925), at (-237.672, -0.747412, 16.5925), at (-236.178, 0.747412, 16.5925), at (-236.7, 0, 16.575)) Ant01_Feed_A_Cu0.face(at (-243.869, 1.53179, 17.3875), at (-241.996, 2.02254, 17.3875), at (-238.949, 2.24903, 17.405), at (-241.793, 1.04104, 17.3875), at (-239.423, 2.72271, 17.3875), at (-238.723, 5.29587, 17.3875), at (-238.232, 7.16884, 17.3875), at (-237.741, 5.09259, 17.3875), at (-238.061, 2.69602, 17.3875), at (-236.235, 0.22882, 17.3875), at (-234.615, -2.0849, 17.3875), at (-236.929, -0.465205, 17.3875)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) Ant01_Feed_A_Cu1.face(at (-233.802, -2.89815, 17.405), at (-233.455, -2.55114, 17.3875), at (-233.657, -3.04303, 17.3875), at (-234.149, -3.24516, 17.3875), at (-233.767, -2.93343, 17.3875)) Ant01_Feed_B_Inner_Cu0.face(at (-235.674, 1.71979, 17.3875), at (-234.615, 2.0849, 17.3875), at (-235.327, 1.37278, 17.405), at (-236.22, 0.480479, 17.3875), at (-234.98, 1.02576, 17.3875), at (-236.178, 0.747412, 17.3875)) Ant01_Feed_B_Inner_Cu1.face(at (-234.149, 3.24516, 17.3875), at (-233.657, 3.04303, 17.3875), at (-233.802, 2.89815, 17.405), at (-233.455, 2.55114, 17.3875), at (-233.767, 2.93343, 17.3875)) Ant01_Feed_B_Outer.face(at (-243.869, -1.53179, 17.3875), at (-241.793, -1.04104, 17.3875), at (-239.396, -1.36136, 17.3875), at (-238.302, -0.907572, 17.3875), at (-237.18, -0.480479, 17.3875), at (-237.608, -1.6016, 17.3875), at (-238.061, -2.69602, 17.3875), at (-237.741, -5.09259, 17.3875), at (-238.232, -7.16884, 17.3875), at (-238.723, -5.29587, 17.3875), at (-239.423, -2.72271, 17.3875), at (-241.996, -2.02254, 17.3875)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) Ant01_Ring_Q1.face(at (-225.882, 10.8183, 16.5925), at (-223.451, 6.62457, 16.5925), at (-225.749, 2.56301, 16.5925), at (-231.171, 0.264435, 16.5925), at (-235.364, 1.3356, 16.5925), at (-236.436, 5.52938, 16.5925), at (-234.137, 10.9506, 16.5925), at (-230.075, 13.2491, 16.5925), at (-235.461, 2.50917, 16.5925), at (-226.162, 3.85988, 16.5925), at (-224.733, 6.62457, 16.5925), at (-226.736, 9.96356, 16.5925)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) Ant01_Ring_Q2.face(at (-242.294, 0.267527, 16.5925), at (-247.779, 2.59297, 16.5925), at (-250.104, 6.70202, 16.5925), at (-247.645, 10.9448, 16.5925), at (-243.402, 13.404, 16.5925), at (-239.293, 11.0786, 16.5925), at (-236.968, 5.59403, 16.5925), at (-238.051, 1.35121, 16.5925), at (-239.159, 7.16143, 16.5925), at (-240.605, 10.6611, 16.5925), at (-243.402, 12.1069, 16.5925), at (-246.78, 10.0801, 16.5925)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) Ant01_Ring_Q3.face(at (-239.263, -10.9506, 16.5925), at (-243.325, -13.2491, 16.5925), at (-247.518, -10.8183, 16.5925), at (-249.949, -6.62457, 16.5925), at (-247.651, -2.56301, 16.5925), at (-242.229, -0.264435, 16.5925), at (-238.036, -1.3356, 16.5925), at (-236.964, -5.52938, 16.5925), at (-240.44, -3.73968, 16.5925), at (-243.779, -2.43079, 16.5925), at (-247.238, -3.85988, 16.5925), at (-248.667, -6.62457, 16.5925)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) Ant01_Ring_Q4.face(at (-223.296, -6.70202, 16.5925), at (-225.755, -10.9448, 16.5925), at (-229.998, -13.404, 16.5925), at (-234.107, -11.0786, 16.5925), at (-236.432, -5.59403, 16.5925), at (-235.349, -1.35121, 16.5925), at (-231.106, -0.267527, 16.5925), at (-225.621, -2.59297, 16.5925), at (-229.998, -12.1069, 16.5925), at (-226.62, -10.0801, 16.5925), at (-224.593, -6.70202, 16.5925), at (-226.039, -3.90501, 16.5925)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) Ant02_Crossover_Bridge.face(at (-184.447, 0.347013, 16.5925), at (-183.086, 1.01434, 16.5925), at (-183.753, -0.347013, 16.5925), at (-185.114, -1.01434, 16.5925), at (-185.072, -0.747412, 16.5925), at (-183.578, 0.747412, 16.5925), at (-184.1, 0, 16.575)) Ant02_Feed_A_Cu0.face(at (-191.269, 1.53179, 17.3875), at (-189.396, 2.02254, 17.3875), at (-186.349, 2.24903, 17.405), at (-189.193, 1.04104, 17.3875), at (-186.823, 2.72271, 17.3875), at (-186.123, 5.29587, 17.3875), at (-185.632, 7.16884, 17.3875), at (-185.141, 5.09259, 17.3875), at (-185.461, 2.69602, 17.3875), at (-183.635, 0.22882, 17.3875), at (-182.015, -2.0849, 17.3875), at (-184.329, -0.465205, 17.3875)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) Ant02_Feed_A_Cu1.face(at (-181.202, -2.89815, 17.405), at (-180.855, -2.55114, 17.3875), at (-181.057, -3.04303, 17.3875), at (-181.549, -3.24516, 17.3875), at (-181.167, -2.93343, 17.3875)) Ant02_Feed_B_Inner_Cu0.face(at (-183.074, 1.71979, 17.3875), at (-182.015, 2.0849, 17.3875), at (-182.727, 1.37278, 17.405), at (-183.62, 0.480479, 17.3875), at (-182.38, 1.02576, 17.3875), at (-183.578, 0.747412, 17.3875)) Ant02_Feed_B_Inner_Cu1.face(at (-181.549, 3.24516, 17.3875), at (-181.057, 3.04303, 17.3875), at (-181.202, 2.89815, 17.405), at (-180.855, 2.55114, 17.3875), at (-181.167, 2.93343, 17.3875)) Ant02_Feed_B_Outer.face(at (-191.269, -1.53179, 17.3875), at (-189.193, -1.04104, 17.3875), at (-186.796, -1.36136, 17.3875), at (-185.702, -0.907572, 17.3875), at (-184.58, -0.480479, 17.3875), at (-185.008, -1.6016, 17.3875), at (-185.461, -2.69602, 17.3875), at (-185.141, -5.09259, 17.3875), at (-185.632, -7.16884, 17.3875), at (-186.123, -5.29587, 17.3875), at (-186.823, -2.72271, 17.3875), at (-189.396, -2.02254, 17.3875)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) Ant02_Ring_Q1.face(at (-173.282, 10.8183, 16.5925), at (-170.851, 6.62457, 16.5925), at (-173.149, 2.56301, 16.5925), at (-178.571, 0.264435, 16.5925), at (-182.764, 1.3356, 16.5925), at (-183.836, 5.52938, 16.5925), at (-181.537, 10.9506, 16.5925), at (-177.475, 13.2491, 16.5925), at (-182.861, 2.50917, 16.5925), at (-173.562, 3.85988, 16.5925), at (-172.133, 6.62457, 16.5925), at (-174.136, 9.96356, 16.5925)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) Ant02_Ring_Q2.face(at (-189.694, 0.267527, 16.5925), at (-195.179, 2.59297, 16.5925), at (-197.504, 6.70202, 16.5925), at (-195.045, 10.9448, 16.5925), at (-190.802, 13.404, 16.5925), at (-186.693, 11.0786, 16.5925), at (-184.368, 5.59403, 16.5925), at (-185.451, 1.35121, 16.5925), at (-186.559, 7.16143, 16.5925), at (-188.005, 10.6611, 16.5925), at (-190.802, 12.1069, 16.5925), at (-194.18, 10.0801, 16.5925)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) Ant02_Ring_Q3.face(at (-186.663, -10.9506, 16.5925), at (-190.725, -13.2491, 16.5925), at (-194.918, -10.8183, 16.5925), at (-197.349, -6.62457, 16.5925), at (-195.051, -2.56301, 16.5925), at (-189.629, -0.264435, 16.5925), at (-185.436, -1.3356, 16.5925), at (-184.364, -5.52938, 16.5925), at (-187.84, -3.73968, 16.5925), at (-191.179, -2.43079, 16.5925), at (-194.638, -3.85988, 16.5925), at (-196.067, -6.62457, 16.5925)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) Ant02_Ring_Q4.face(at (-170.696, -6.70202, 16.5925), at (-173.155, -10.9448, 16.5925), at (-177.398, -13.404, 16.5925), at (-181.507, -11.0786, 16.5925), at (-183.832, -5.59403, 16.5925), at (-182.749, -1.35121, 16.5925), at (-178.506, -0.267527, 16.5925), at (-173.021, -2.59297, 16.5925), at (-177.398, -12.1069, 16.5925), at (-174.02, -10.0801, 16.5925), at (-171.993, -6.70202, 16.5925), at (-173.439, -3.90501, 16.5925)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) Ant03_Crossover_Bridge.face(at (-131.847, 0.347013, 16.5925), at (-130.486, 1.01434, 16.5925), at (-131.153, -0.347013, 16.5925), at (-132.514, -1.01434, 16.5925), at (-132.472, -0.747412, 16.5925), at (-130.978, 0.747412, 16.5925), at (-131.5, 0, 16.575)) Ant03_Feed_A_Cu0.face(at (-138.669, 1.53179, 17.3875), at (-136.796, 2.02254, 17.3875), at (-133.749, 2.24903, 17.405), at (-136.593, 1.04104, 17.3875), at (-134.223, 2.72271, 17.3875), at (-133.523, 5.29587, 17.3875), at (-133.032, 7.16884, 17.3875), at (-132.541, 5.09259, 17.3875), at (-132.861, 2.69602, 17.3875), at (-131.035, 0.22882, 17.3875), at (-129.415, -2.0849, 17.3875), at (-131.729, -0.465205, 17.3875)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) Ant03_Feed_A_Cu1.face(at (-128.602, -2.89815, 17.405), at (-128.255, -2.55114, 17.3875), at (-128.457, -3.04303, 17.3875), at (-128.949, -3.24516, 17.3875), at (-128.567, -2.93343, 17.3875)) Ant03_Feed_B_Inner_Cu0.face(at (-130.474, 1.71979, 17.3875), at (-129.415, 2.0849, 17.3875), at (-130.127, 1.37278, 17.405), at (-131.02, 0.480479, 17.3875), at (-129.78, 1.02576, 17.3875), at (-130.978, 0.747412, 17.3875)) Ant03_Feed_B_Inner_Cu1.face(at (-128.949, 3.24516, 17.3875), at (-128.457, 3.04303, 17.3875), at (-128.602, 2.89815, 17.405), at (-128.255, 2.55114, 17.3875), at (-128.567, 2.93343, 17.3875)) Ant03_Feed_B_Outer.face(at (-138.669, -1.53179, 17.3875), at (-136.593, -1.04104, 17.3875), at (-134.196, -1.36136, 17.3875), at (-133.102, -0.907572, 17.3875), at (-131.98, -0.480479, 17.3875), at (-132.408, -1.6016, 17.3875), at (-132.861, -2.69602, 17.3875), at (-132.541, -5.09259, 17.3875), at (-133.032, -7.16884, 17.3875), at (-133.523, -5.29587, 17.3875), at (-134.223, -2.72271, 17.3875), at (-136.796, -2.02254, 17.3875)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) Ant03_Ring_Q1.face(at (-120.682, 10.8183, 16.5925), at (-118.251, 6.62457, 16.5925), at (-120.549, 2.56301, 16.5925), at (-125.971, 0.264435, 16.5925), at (-130.164, 1.3356, 16.5925), at (-131.236, 5.52938, 16.5925), at (-128.937, 10.9506, 16.5925), at (-124.875, 13.2491, 16.5925), at (-130.261, 2.50917, 16.5925), at (-120.962, 3.85988, 16.5925), at (-119.533, 6.62457, 16.5925), at (-121.536, 9.96356, 16.5925)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) Ant03_Ring_Q2.face(at (-137.094, 0.267527, 16.5925), at (-142.579, 2.59297, 16.5925), at (-144.904, 6.70202, 16.5925), at (-142.445, 10.9448, 16.5925), at (-138.202, 13.404, 16.5925), at (-134.093, 11.0786, 16.5925), at (-131.768, 5.59403, 16.5925), at (-132.851, 1.35121, 16.5925), at (-133.959, 7.16143, 16.5925), at (-135.405, 10.6611, 16.5925), at (-138.202, 12.1069, 16.5925), at (-141.58, 10.0801, 16.5925)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) Ant03_Ring_Q3.face(at (-134.063, -10.9506, 16.5925), at (-138.125, -13.2491, 16.5925), at (-142.318, -10.8183, 16.5925), at (-144.749, -6.62457, 16.5925), at (-142.451, -2.56301, 16.5925), at (-137.029, -0.264435, 16.5925), at (-132.836, -1.3356, 16.5925), at (-131.764, -5.52938, 16.5925), at (-135.24, -3.73968, 16.5925), at (-138.579, -2.43079, 16.5925), at (-142.038, -3.85988, 16.5925), at (-143.467, -6.62457, 16.5925)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) Ant03_Ring_Q4.face(at (-118.096, -6.70202, 16.5925), at (-120.555, -10.9448, 16.5925), at (-124.798, -13.404, 16.5925), at (-128.907, -11.0786, 16.5925), at (-131.232, -5.59403, 16.5925), at (-130.149, -1.35121, 16.5925), at (-125.906, -0.267527, 16.5925), at (-120.421, -2.59297, 16.5925), at (-124.798, -12.1069, 16.5925), at (-121.42, -10.0801, 16.5925), at (-119.393, -6.70202, 16.5925), at (-120.839, -3.90501, 16.5925)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) Ant04_Crossover_Bridge.face(at (-79.247, 0.347013, 16.5925), at (-77.8857, 1.01434, 16.5925), at (-78.553, -0.347013, 16.5925), at (-79.9143, -1.01434, 16.5925), at (-79.8724, -0.747412, 16.5925), at (-78.3776, 0.747412, 16.5925), at (-78.9, 0, 16.575)) Ant04_Feed_A_Cu0.face(at (-86.0688, 1.53179, 17.3875), at (-84.1959, 2.02254, 17.3875), at (-81.149, 2.24903, 17.405), at (-83.9926, 1.04104, 17.3875), at (-81.6227, 2.72271, 17.3875), at (-80.9225, 5.29587, 17.3875), at (-80.4318, 7.16884, 17.3875), at (-79.941, 5.09259, 17.3875), at (-80.2614, 2.69602, 17.3875), at (-78.4348, 0.22882, 17.3875), at (-76.8151, -2.0849, 17.3875), at (-79.1288, -0.465205, 17.3875)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) Ant04_Feed_A_Cu1.face(at (-76.0019, -2.89815, 17.405), at (-75.6548, -2.55114, 17.3875), at (-75.857, -3.04303, 17.3875), at (-76.3489, -3.24516, 17.3875), at (-75.9666, -2.93343, 17.3875)) Ant04_Feed_B_Inner_Cu0.face(at (-77.8742, 1.71979, 17.3875), at (-76.8151, 2.0849, 17.3875), at (-77.5272, 1.37278, 17.405), at (-78.4195, 0.480479, 17.3875), at (-77.1802, 1.02576, 17.3875), at (-78.3776, 0.747412, 17.3875)) Ant04_Feed_B_Inner_Cu1.face(at (-76.3489, 3.24516, 17.3875), at (-75.857, 3.04303, 17.3875), at (-76.0019, 2.89815, 17.405), at (-75.6548, 2.55114, 17.3875), at (-75.9666, 2.93343, 17.3875)) Ant04_Feed_B_Outer.face(at (-86.0688, -1.53179, 17.3875), at (-83.9926, -1.04104, 17.3875), at (-81.596, -1.36136, 17.3875), at (-80.5016, -0.907572, 17.3875), at (-79.3805, -0.480479, 17.3875), at (-79.8076, -1.6016, 17.3875), at (-80.2614, -2.69602, 17.3875), at (-79.941, -5.09259, 17.3875), at (-80.4318, -7.16884, 17.3875), at (-80.9225, -5.29587, 17.3875), at (-81.6227, -2.72271, 17.3875), at (-84.1959, -2.02254, 17.3875)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) Ant04_Ring_Q1.face(at (-68.0817, 10.8183, 16.5925), at (-65.6509, 6.62457, 16.5925), at (-67.9494, 2.56301, 16.5925), at (-73.3706, 0.264435, 16.5925), at (-77.5644, 1.3356, 16.5925), at (-78.6356, 5.52938, 16.5925), at (-76.337, 10.9506, 16.5925), at (-72.2754, 13.2491, 16.5925), at (-77.6613, 2.50917, 16.5925), at (-68.3621, 3.85988, 16.5925), at (-66.933, 6.62457, 16.5925), at (-68.9364, 9.96356, 16.5925)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) Ant04_Ring_Q2.face(at (-84.494, 0.267527, 16.5925), at (-89.9786, 2.59297, 16.5925), at (-92.304, 6.70202, 16.5925), at (-89.8448, 10.9448, 16.5925), at (-85.602, 13.404, 16.5925), at (-81.493, 11.0786, 16.5925), at (-79.1675, 5.59403, 16.5925), at (-80.2512, 1.35121, 16.5925), at (-81.3592, 7.16143, 16.5925), at (-82.805, 10.6611, 16.5925), at (-85.602, 12.1069, 16.5925), at (-88.9801, 10.0801, 16.5925)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) Ant04_Ring_Q3.face(at (-81.463, -10.9506, 16.5925), at (-85.5246, -13.2491, 16.5925), at (-89.7183, -10.8183, 16.5925), at (-92.1491, -6.62457, 16.5925), at (-89.8506, -2.56301, 16.5925), at (-84.4294, -0.264435, 16.5925), at (-80.2356, -1.3356, 16.5925), at (-79.1644, -5.52938, 16.5925), at (-82.6397, -3.73968, 16.5925), at (-85.9787, -2.43079, 16.5925), at (-89.4379, -3.85988, 16.5925), at (-90.867, -6.62457, 16.5925)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) Ant04_Ring_Q4.face(at (-65.496, -6.70202, 16.5925), at (-67.9552, -10.9448, 16.5925), at (-72.198, -13.404, 16.5925), at (-76.307, -11.0786, 16.5925), at (-78.6325, -5.59403, 16.5925), at (-77.5488, -1.35121, 16.5925), at (-73.306, -0.267527, 16.5925), at (-67.8214, -2.59297, 16.5925), at (-72.198, -12.1069, 16.5925), at (-68.8199, -10.0801, 16.5925), at (-66.7931, -6.70202, 16.5925), at (-68.2389, -3.90501, 16.5925)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)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 Frequency=0GHz Layers{Layer1{Thickness=0.0254um Material=Ouro_vol_nominal} Layer2{Thickness=4.5um Material=NiP_vol_nominal} Layer3{LayerType=1 Thickness=0 Material=Cobre_vol_Groiss}}
  Open1: Radiation Objects=RadiatingSurface
  E01_A: Lumped Port Objects=E01_A_externo LumpedPortType=Modal Modes{Mode1{IntLine{(-233.59083, -2.5091684, 16.575) -> (-233.35598, -2.5091684, 16.575)} CharImp=Zpi RenormImp=50ohm}} Impedance=50ohm
  E01_B: Lumped Port Objects=E01_B_externo LumpedPortType=Modal Modes{Mode1{IntLine{(-233.59083, 2.5091684, 16.575) -> (-233.35598, 2.5091684, 16.575)} CharImp=Zpi RenormImp=50ohm}} Impedance=50ohm
  E02_A: Lumped Port Objects=E02_A_externo LumpedPortType=Modal Modes{Mode1{IntLine{(-180.99083, -2.5091684, 16.575) -> (-180.75598, -2.5091684, 16.575)} CharImp=Zpi RenormImp=50ohm}} Impedance=50ohm
  E02_B: Lumped Port Objects=E02_B_externo LumpedPortType=Modal Modes{Mode1{IntLine{(-180.99083, 2.5091684, 16.575) -> (-180.75598, 2.5091684, 16.575)} CharImp=Zpi RenormImp=50ohm}} Impedance=50ohm
  E03_A: Lumped Port Objects=E03_A_externo LumpedPortType=Modal Modes{Mode1{IntLine{(-128.39083, -2.5091684, 16.575) -> (-128.15598, -2.5091684, 16.575)} CharImp=Zpi RenormImp=50ohm}} Impedance=50ohm
  E03_B: Lumped Port Objects=E03_B_externo LumpedPortType=Modal Modes{Mode1{IntLine{(-128.39083, 2.5091684, 16.575) -> (-128.15598, 2.5091684, 16.575)} CharImp=Zpi RenormImp=50ohm}} Impedance=50ohm
  E04_A: Lumped Port Objects=E04_A_externo LumpedPortType=Modal Modes{Mode1{IntLine{(-75.790832, -2.5091684, 16.575) -> (-75.555976, -2.5091684, 16.575)} CharImp=Zpi RenormImp=50ohm}} Impedance=50ohm
  E04_B: Lumped Port Objects=E04_B_externo LumpedPortType=Modal Modes{Mode1{IntLine{(-75.790832, 2.5091684, 16.575) -> (-75.555976, 2.5091684, 16.575)} CharImp=Zpi RenormImp=50ohm}} Impedance=50ohm
  E05_A: Lumped Port Objects=E05_A_externo LumpedPortType=Modal Modes{Mode1{IntLine{(-23.190832, -2.5091684, 16.575) -> (-22.955976, -2.5091684, 16.575)} CharImp=Zpi RenormImp=50ohm}} Impedance=50ohm
  E05_B: Lumped Port Objects=E05_B_externo LumpedPortType=Modal Modes{Mode1{IntLine{(-23.190832, 2.5091684, 16.575) -> (-22.955976, 2.5091684, 16.575)} CharImp=Zpi RenormImp=50ohm}} Impedance=50ohm
  E06_A: Lumped Port Objects=E06_A_externo LumpedPortType=Modal Modes{Mode1{IntLine{(29.409168, -2.5091684, 16.575) -> (29.644024, -2.5091684, 16.575)} CharImp=Zpi RenormImp=50ohm}} Impedance=50ohm
  E06_B: Lumped Port Objects=E06_B_externo LumpedPortType=Modal Modes{Mode1{IntLine{(29.409168, 2.5091684, 16.575) -> (29.644024, 2.5091684, 16.575)} CharImp=Zpi RenormImp=50ohm}} Impedance=50ohm
  E07_A: Lumped Port Objects=E07_A_externo LumpedPortType=Modal Modes{Mode1{IntLine{(82.009168, -2.5091684, 16.575) -> (82.244024, -2.5091684, 16.575)} CharImp=Zpi RenormImp=50ohm}} Impedance=50ohm
  E07_B: Lumped Port Objects=E07_B_externo LumpedPortType=Modal Modes{Mode1{IntLine{(82.009168, 2.5091684, 16.575) -> (82.244024, 2.5091684, 16.575)} CharImp=Zpi RenormImp=50ohm}} Impedance=50ohm
  E08_A: Lumped Port Objects=E08_A_externo LumpedPortType=Modal Modes{Mode1{IntLine{(134.60917, -2.5091684, 16.575) -> (134.84402, -2.5091684, 16.575)} CharImp=Zpi RenormImp=50ohm}} Impedance=50ohm
  E08_B: Lumped Port Objects=E08_B_externo LumpedPortType=Modal Modes{Mode1{IntLine{(134.60917, 2.5091684, 16.575) -> (134.84402, 2.5091684, 16.575)} CharImp=Zpi RenormImp=50ohm}} Impedance=50ohm
  E09_A: Lumped Port Objects=E09_A_externo LumpedPortType=Modal Modes{Mode1{IntLine{(187.20917, -2.5091684, 16.575) -> (187.44402, -2.5091684, 16.575)} CharImp=Zpi RenormImp=50ohm}} Impedance=50ohm
  E09_B: Lumped Port Objects=E09_B_externo LumpedPortType=Modal Modes{Mode1{IntLine{(187.20917, 2.5091684, 16.575) -> (187.44402, 2.5091684, 16.575)} CharImp=Zpi RenormImp=50ohm}} Impedance=50ohm
  E10_A: Lumped Port Objects=E10_A_externo LumpedPortType=Modal Modes{Mode1{IntLine{(239.80917, -2.5091684, 16.575) -> (240.04402, -2.5091684, 16.575)} CharImp=Zpi RenormImp=50ohm}} Impedance=50ohm
  E10_B: Lumped Port Objects=E10_B_externo LumpedPortType=Modal Modes{Mode1{IntLine{(239.80917, 2.5091684, 16.575) -> (240.04402, 2.5091684, 16.575)} CharImp=Zpi RenormImp=50ohm}} Impedance=50ohm
mesh:
  Vias_curvatura: SurfApproxBased Objects=[Via09_1, Via09_0, Via08_1, Via08_0, Via07_1, Via07_0, Via06_1, Via06_0, Via05_1, Via05_0, Via04_1, Via04_0, Via03_1, Via03_0, Via02_1, Via02_0, Via01_1, Via01_0, Via00_1, Via00_0] CurvedSurfaceApproxChoice=ManualSettings SurfDev=0.002mm NormalDev=10deg
  Cobre_solda_curvatura: SurfApproxBased Objects=[Ant10_Feed_B_Inner_Cu1, Ant10_Feed_A_Cu1, Ant09_Feed_B_Inner_Cu1, Ant09_Feed_A_Cu1, Ant08_Feed_B_Inner_Cu1, Ant08_Feed_A_Cu1, Ant07_Feed_B_Inner_Cu1, Ant07_Feed_A_Cu1, Ant06_Feed_B_Inner_Cu1, Ant06_Feed_A_Cu1, Ant05_Feed_B_Inner_Cu1, Ant05_Feed_A_Cu1, Ant04_Feed_B_Inner_Cu1, Ant04_Feed_A_Cu1, Ant03_Feed_B_Inner_Cu1, Ant03_Feed_A_Cu1, Ant02_Feed_B_Inner_Cu1, Ant02_Feed_A_Cu1, Ant01_Feed_B_Inner_Cu1, Ant01_Feed_A_Cu1, Solda_terminal_39, Solda_terminal_38, Solda_terminal_37, Solda_terminal_36, Solda_terminal_35, Solda_terminal_34, Solda_terminal_33, Solda_terminal_32, Solda_terminal_31, Solda_terminal_30, Solda_terminal_29, Solda_terminal_28, Solda_terminal_27, Solda_terminal_26, Solda_terminal_25, Solda_terminal_24, Solda_terminal_23, Solda_terminal_22, Solda_terminal_21, Solda_terminal_20, Solda_terminal_19, Solda_terminal_18, Solda_terminal_17, Solda_terminal_16, Solda_terminal_15, Solda_terminal_14, Solda_terminal_13, Solda_terminal_12, Solda_terminal_11, Solda_terminal_10, Solda_terminal_09, Solda_terminal_08, Solda_terminal_07, Solda_terminal_06, Solda_terminal_05, Solda_terminal_04, Solda_terminal_03, Solda_terminal_02, Solda_terminal_01, Solda_terminal_00] CurvedSurfaceApproxChoice=ManualSettings SurfDev=0.0005mm NormalDev=5deg
  Fragmentos_60um: LengthBased Objects=[Ant10_Feed_B_Inner_Cu1, Ant10_Feed_A_Cu1, Ant09_Feed_B_Inner_Cu1, Ant09_Feed_A_Cu1, Ant08_Feed_B_Inner_Cu1, Ant08_Feed_A_Cu1, Ant07_Feed_B_Inner_Cu1, Ant07_Feed_A_Cu1, Ant06_Feed_B_Inner_Cu1, Ant06_Feed_A_Cu1, Ant05_Feed_B_Inner_Cu1, Ant05_Feed_A_Cu1, Ant04_Feed_B_Inner_Cu1, Ant04_Feed_A_Cu1, Ant03_Feed_B_Inner_Cu1, Ant03_Feed_A_Cu1, Ant02_Feed_B_Inner_Cu1, Ant02_Feed_A_Cu1, Ant01_Feed_B_Inner_Cu1, Ant01_Feed_A_Cu1] MaxLength=0.06mm
setups:
  Banda: HfssDriven Frequency=5.17GHz MaxDeltaS=0.004 MaximumPasses=25 MinimumPasses=23 MinimumConvergedPasses=2 PercentRefinement=5 BasisOrder=0 PortAccuracy=2 DrivenSolverType="Iterative Solver" IterativeResidual=1e-05 DDMSolverResidual=1e-05 ExpressionCache{CacheItem{Title=G_P0_P90 Expression=dB(RealizedGainTotal) Intrinsics="Phi='90deg' Theta='0deg'" IsConvergence UseRelativeConvergence=0 MaxConvergenceDelta=0.02 MaxConvergeValue=0.02 TraceID=672 ReportType=3} CacheItem{Title=G_M60_P90 Expression=dB(RealizedGainTotal) Intrinsics="Phi='90deg' Theta='-60deg'" IsConvergence UseRelativeConvergence=0 MaxConvergenceDelta=0.02 MaxConvergeValue=0.02 TraceID=673 ReportType=3} CacheItem{Title=G_M50_P90 Expression=dB(RealizedGainTotal) Intrinsics="Phi='90deg' Theta='-50deg'" IsConvergence UseRelativeConvergence=0 MaxConvergenceDelta=0.02 MaxConvergeValue=0.02 TraceID=674 ReportType=3} CacheItem{Title=G_M40_P90 Expression=dB(RealizedGainTotal) Intrinsics="Phi='90deg' Theta='-40deg'" IsConvergence UseRelativeConvergence=0 MaxConvergenceDelta=0.02 MaxConvergeValue=0.02 TraceID=675 ReportType=3} CacheItem{Title=G_P40_P90 Expression=dB(RealizedGainTotal) Intrinsics="Phi='90deg' Theta='40deg'" IsConvergence UseRelativeConvergence=0 MaxConvergenceDelta=0.02 MaxConvergeValue=0.02 TraceID=676 ReportType=3} CacheItem{Title=G_P50_P90 Expression=dB(RealizedGainTotal) Intrinsics="Phi='90deg' Theta='50deg'" IsConvergence UseRelativeConvergence=0 MaxConvergenceDelta=0.02 MaxConvergeValue=0.02 TraceID=677 ReportType=3} CacheItem{Title=G_P60_P90 Expression=dB(RealizedGainTotal) Intrinsics="Phi='90deg' Theta='60deg'" IsConvergence UseRelativeConvergence=0 MaxConvergenceDelta=0.02 MaxConvergeValue=0.02 TraceID=678 ReportType=3} CacheItem{Title=G_M3_P0 Expression=dB(RealizedGainTotal) Intrinsics="Phi='0deg' Theta='-3deg'" IsConvergence UseRelativeConvergence=0 MaxConvergenceDelta=0.02 MaxConvergeValue=0.02 TraceID=679 ReportType=3} CacheItem{Title=G_P3_P0 Expression=dB(RealizedGainTotal) Intrinsics="Phi='0deg' Theta='3deg'" IsConvergence UseRelativeConvergence=0 MaxConvergenceDelta=0.02 MaxConvergeValue=0.02 TraceID=680 ReportType=3}}
source amplitudes:
  E01_A:1, E01_B:1, E02_A:1, E02_B:1, E03_A:1, E03_B:1, E04_A:1, E04_B:1, E05_A:1, E05_B:1, E06_A:1, E06_B:1, E07_A:1, E07_B:1, E08_A:1, E08_B:1, E09_A:1, E09_B:1, E10_A:1, E10_B:1: 0.05W 0deg
radiation setups:
  3D: Infinite Sphere Theta=0deg..180deg step 2deg Phi=-180deg..180deg step 2deg
  Elevation: Infinite Sphere Theta=-180deg..180deg step 1deg Phi=0deg..90deg step 90deg
  Azimuth: Infinite Sphere Theta=90deg..90deg step 0deg Phi=-180deg..180deg step 1deg
  HV: Infinite Sphere Theta=-180deg..180deg step 0.25deg Phi=0deg..90deg step 90deg
reports:
  H: dB(RealizedGainTotal), dB(GainTotal), dB(DirTotal) vs Theta on Banda : LastAdaptive, HV [Phi=90deg Freq=5.17GHz]
  V: dB(RealizedGainTotal), dB(GainTotal), dB(DirTotal) vs Theta on Banda : LastAdaptive, HV [Phi=0deg Freq=5.17GHz]
