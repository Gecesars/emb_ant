# Ansys Electronics Desktop project, version 2024.2
materials:
  vacuum: permittivity=1
  RO4350B_R01: permittivity=3.66 dielectric_loss_tangent=0.0037
  PTFE_cabo: permittivity=2.0363635 dielectric_loss_tangent=0.00027683055
  Silicone_nom: permittivity=2.77 dielectric_loss_tangent=0.02
  POM_nom: permittivity=3.4 dielectric_loss_tangent=0.01
  AL5052: conductivity=20000000
  aco_nom: conductivity=1400000
  copper: permeability=0.999991 conductivity=58000000

design Antena_direta (HFSS, HFSS Hybrid Modal Network, model units mm)
geometry:
  AL5052 [AL5052] = imported_body(D:/dev/EMBRAER/P1H/R05_Correcao/face40\antena_direta\cad\AL5052.step)
  Batente_7, Batente_6, Berco_5, Berco_4, Berco_3, Berco_2, Berco_1 [POM_nom] = imported_body(D:/dev/EMBRAER/P1H/R05_Correcao/face40\antena_direta\cad\POM_nom.step)
  Isol_SUP_B3, Isol_SUP_A3, Isol_SUP_B4, Isol_SUP_B2, Isol_SUP_A4, Isol_SUP_A2, Isol_SUP_B5, Isol_SUP_B1, Isol_SUP_A5, Isol_SUP_A1, Isol_INF_B3, Isol_INF_A3, Isol_INF_B4, Isol_INF_B2, Isol_INF_A4, Isol_INF_A2, Isol_INF_B5, Isol_INF_B1, Isol_INF_A5, Isol_INF_A1 [PTFE_cabo] = imported_body(D:/dev/EMBRAER/P1H/R05_Correcao/face40\antena_direta\cad\PTFE_cabo.step)
  RO4350B_R01 [RO4350B_R01] = imported_body(D:/dev/EMBRAER/P1H/R05_Correcao/face40\antena_direta\cad\RO4350B_R01.step)
  Passa_cabos_10, Passa_cabos_09, Passa_cabos_08, Passa_cabos_07, Passa_cabos_06, Passa_cabos_05, Passa_cabos_04, Passa_cabos_03, Passa_cabos_02, Passa_cabos_01 [Silicone_nom] = imported_body(D:/dev/EMBRAER/P1H/R05_Correcao/face40\antena_direta\cad\Silicone_nom.step)
  Par_6_004, Par_6_004_1, Par_6_003, Par_6_002, Par_6_002_1, Par_6_001, Par_5_004, Par_5_004_1, Par_5_003, Par_5_002, Par_5_002_1, Par_5_001, Par_4_004, Par_4_004_1, Par_4_003, Par_4_002, Par_4_002_1, Par_4_001, Par_3_004, Par_3_004_1, Par_3_003, Par_3_002, Par_3_002_1, Par_3_001, Par_2_004, Par_2_004_1, Par_2_003, Par_2_002, Par_2_002_1, Par_2_001, Par_1_004, Par_1_004_1, Par_1_003, Par_1_002, Par_1_002_1, Par_1_001, Par_0_004, Par_0_004_1, Par_0_003, Par_0_002, Par_0_002_1, Par_0_001 [aco_nom] = imported_body(D:/dev/EMBRAER/P1H/R05_Correcao/face40\antena_direta\cad\aco_nom.step)
  Capa_SUP_B3, Sinal_SUP_B3, Capa_SUP_A3, Sinal_SUP_A3, Capa_SUP_B4, Sinal_SUP_B4, Capa_SUP_B2, Sinal_SUP_B2, Capa_SUP_A4, Sinal_SUP_A4, Capa_SUP_A2, Sinal_SUP_A2, Capa_SUP_B5, Sinal_SUP_B5, Capa_SUP_B1, Sinal_SUP_B1, Capa_SUP_A5, Sinal_SUP_A5, Capa_SUP_A1, Sinal_SUP_A1, Capa_INF_B3, Sinal_INF_B3, Capa_INF_A3, Sinal_INF_A3, Capa_INF_B4, Sinal_INF_B4, Capa_INF_B2, Sinal_INF_B2, Capa_INF_A4, Sinal_INF_A4, Capa_INF_A2, Sinal_INF_A2, Capa_INF_B5, Sinal_INF_B5, Capa_INF_B1, Sinal_INF_B1, Capa_INF_A5, Sinal_INF_A5, Capa_INF_A1, Sinal_INF_A1, Via09_1, Via09_0, Via08_1, Via08_0, Via07_1, Via07_0, Via06_1, Via06_0, Via05_1, Via05_0, Via04_1, Via04_0, Via03_1, Via03_0, Via02_1, Via02_0, Via01_1, Via01_0, Via00_1, Via00_0 [copper] = imported_body(D:/dev/EMBRAER/P1H/R05_Correcao/face40\antena_direta\cad\copper.step)
  Ant10_PadB1, Ant10_PadB0, Ant10_Feed_B_Inner, Ant10_Feed_B_Outer, Ant10_Feed_A, Ant10_Crossover_Bridge, Ant10_Ring_Q4, Ant10_Ring_Q3, Ant10_Ring_Q2, Ant10_Ring_Q1, Ant09_PadB1, Ant09_PadB0, Ant09_Feed_B_Inner, Ant09_Feed_B_Outer, Ant09_Feed_A, Ant09_Crossover_Bridge, Ant09_Ring_Q4, Ant09_Ring_Q3, Ant09_Ring_Q2, Ant09_Ring_Q1, Ant08_PadB1, Ant08_PadB0, Ant08_Feed_B_Inner, Ant08_Feed_B_Outer, Ant08_Feed_A, Ant08_Crossover_Bridge, Ant08_Ring_Q4, Ant08_Ring_Q3, Ant08_Ring_Q2, Ant08_Ring_Q1, Ant07_PadB1, Ant07_PadB0, Ant07_Feed_B_Inner, Ant07_Feed_B_Outer, Ant07_Feed_A, Ant07_Crossover_Bridge, Ant07_Ring_Q4, Ant07_Ring_Q3, Ant07_Ring_Q2, Ant07_Ring_Q1, Ant06_PadB1, Ant06_PadB0, Ant06_Feed_B_Inner, Ant06_Feed_B_Outer, Ant06_Feed_A, Ant06_Crossover_Bridge, Ant06_Ring_Q4, Ant06_Ring_Q3, Ant06_Ring_Q2, Ant06_Ring_Q1, Ant05_PadB1, Ant05_PadB0, Ant05_Feed_B_Inner, Ant05_Feed_B_Outer, Ant05_Feed_A, Ant05_Crossover_Bridge, Ant05_Ring_Q4, Ant05_Ring_Q3, Ant05_Ring_Q2, Ant05_Ring_Q1, Ant04_PadB1, Ant04_PadB0, Ant04_Feed_B_Inner, Ant04_Feed_B_Outer, Ant04_Feed_A, Ant04_Crossover_Bridge, Ant04_Ring_Q4, Ant04_Ring_Q3, Ant04_Ring_Q2, Ant04_Ring_Q1, Ant03_PadB1, Ant03_PadB0, Ant03_Feed_B_Inner, Ant03_Feed_B_Outer, Ant03_Feed_A, Ant03_Crossover_Bridge, Ant03_Ring_Q4, Ant03_Ring_Q3, Ant03_Ring_Q2, Ant03_Ring_Q1, Ant02_PadB1, Ant02_PadB0, Ant02_Feed_B_Inner, Ant02_Feed_B_Outer, Ant02_Feed_A, Ant02_Crossover_Bridge, Ant02_Ring_Q4, Ant02_Ring_Q3, Ant02_Ring_Q2, Ant02_Ring_Q1, Ant01_PadB1, Ant01_PadB0, Ant01_Feed_B_Inner, Ant01_Feed_B_Outer, Ant01_Feed_A, Ant01_Crossover_Bridge, Ant01_Ring_Q4, Ant01_Ring_Q3, Ant01_Ring_Q2, Ant01_Ring_Q1 = imported_body(D:/dev/EMBRAER/P1H/R05_Correcao/face40\antena_direta\cad\folha_cu.step)
  E01_A_externo = circle(normal=Z, centre=(-234.19083mm, -2.5091684mm, -4mm), radius=1.515mm)
  E01_A_interno = circle(normal=Z, centre=(-234.19083mm, -2.5091684mm, -4mm), radius=0.45975mm)
  E01_A_externo.subtract(E01_A_interno)
  E01_B_externo = circle(normal=Z, centre=(-234.19083mm, 2.5091684mm, -4mm), radius=1.515mm)
  E01_B_interno = circle(normal=Z, centre=(-234.19083mm, 2.5091684mm, -4mm), radius=0.45975mm)
  E01_B_externo.subtract(E01_B_interno)
  E02_A_externo = circle(normal=Z, centre=(-181.59083mm, -2.5091684mm, -4mm), radius=1.515mm)
  E02_A_interno = circle(normal=Z, centre=(-181.59083mm, -2.5091684mm, -4mm), radius=0.45975mm)
  E02_A_externo.subtract(E02_A_interno)
  E02_B_externo = circle(normal=Z, centre=(-181.59083mm, 2.5091684mm, -4mm), radius=1.515mm)
  E02_B_interno = circle(normal=Z, centre=(-181.59083mm, 2.5091684mm, -4mm), radius=0.45975mm)
  E02_B_externo.subtract(E02_B_interno)
  E03_A_externo = circle(normal=Z, centre=(-128.99083mm, -2.5091684mm, -4mm), radius=1.515mm)
  E03_A_interno = circle(normal=Z, centre=(-128.99083mm, -2.5091684mm, -4mm), radius=0.45975mm)
  E03_A_externo.subtract(E03_A_interno)
  E03_B_externo = circle(normal=Z, centre=(-128.99083mm, 2.5091684mm, -4mm), radius=1.515mm)
  E03_B_interno = circle(normal=Z, centre=(-128.99083mm, 2.5091684mm, -4mm), radius=0.45975mm)
  E03_B_externo.subtract(E03_B_interno)
  E04_A_externo = circle(normal=Z, centre=(-76.390832mm, -2.5091684mm, -4mm), radius=1.515mm)
  E04_A_interno = circle(normal=Z, centre=(-76.390832mm, -2.5091684mm, -4mm), radius=0.45975mm)
  E04_A_externo.subtract(E04_A_interno)
  E04_B_externo = circle(normal=Z, centre=(-76.390832mm, 2.5091684mm, -4mm), radius=1.515mm)
  E04_B_interno = circle(normal=Z, centre=(-76.390832mm, 2.5091684mm, -4mm), radius=0.45975mm)
  E04_B_externo.subtract(E04_B_interno)
  E05_A_externo = circle(normal=Z, centre=(-23.790832mm, -2.5091684mm, -4mm), radius=1.515mm)
  E05_A_interno = circle(normal=Z, centre=(-23.790832mm, -2.5091684mm, -4mm), radius=0.45975mm)
  E05_A_externo.subtract(E05_A_interno)
  E05_B_externo = circle(normal=Z, centre=(-23.790832mm, 2.5091684mm, -4mm), radius=1.515mm)
  E05_B_interno = circle(normal=Z, centre=(-23.790832mm, 2.5091684mm, -4mm), radius=0.45975mm)
  E05_B_externo.subtract(E05_B_interno)
  E06_A_externo = circle(normal=Z, centre=(28.809168mm, -2.5091684mm, -4mm), radius=1.515mm)
  E06_A_interno = circle(normal=Z, centre=(28.809168mm, -2.5091684mm, -4mm), radius=0.45975mm)
  E06_A_externo.subtract(E06_A_interno)
  E06_B_externo = circle(normal=Z, centre=(28.809168mm, 2.5091684mm, -4mm), radius=1.515mm)
  E06_B_interno = circle(normal=Z, centre=(28.809168mm, 2.5091684mm, -4mm), radius=0.45975mm)
  E06_B_externo.subtract(E06_B_interno)
  E07_A_externo = circle(normal=Z, centre=(81.409168mm, -2.5091684mm, -4mm), radius=1.515mm)
  E07_A_interno = circle(normal=Z, centre=(81.409168mm, -2.5091684mm, -4mm), radius=0.45975mm)
  E07_A_externo.subtract(E07_A_interno)
  E07_B_externo = circle(normal=Z, centre=(81.409168mm, 2.5091684mm, -4mm), radius=1.515mm)
  E07_B_interno = circle(normal=Z, centre=(81.409168mm, 2.5091684mm, -4mm), radius=0.45975mm)
  E07_B_externo.subtract(E07_B_interno)
  E08_A_externo = circle(normal=Z, centre=(134.00917mm, -2.5091684mm, -4mm), radius=1.515mm)
  E08_A_interno = circle(normal=Z, centre=(134.00917mm, -2.5091684mm, -4mm), radius=0.45975mm)
  E08_A_externo.subtract(E08_A_interno)
  E08_B_externo = circle(normal=Z, centre=(134.00917mm, 2.5091684mm, -4mm), radius=1.515mm)
  E08_B_interno = circle(normal=Z, centre=(134.00917mm, 2.5091684mm, -4mm), radius=0.45975mm)
  E08_B_externo.subtract(E08_B_interno)
  E09_A_externo = circle(normal=Z, centre=(186.60917mm, -2.5091684mm, -4mm), radius=1.515mm)
  E09_A_interno = circle(normal=Z, centre=(186.60917mm, -2.5091684mm, -4mm), radius=0.45975mm)
  E09_A_externo.subtract(E09_A_interno)
  E09_B_externo = circle(normal=Z, centre=(186.60917mm, 2.5091684mm, -4mm), radius=1.515mm)
  E09_B_interno = circle(normal=Z, centre=(186.60917mm, 2.5091684mm, -4mm), radius=0.45975mm)
  E09_B_externo.subtract(E09_B_interno)
  E10_A_externo = circle(normal=Z, centre=(239.20917mm, -2.5091684mm, -4mm), radius=1.515mm)
  E10_A_interno = circle(normal=Z, centre=(239.20917mm, -2.5091684mm, -4mm), radius=0.45975mm)
  E10_A_externo.subtract(E10_A_interno)
  E10_B_externo = circle(normal=Z, centre=(239.20917mm, 2.5091684mm, -4mm), radius=1.515mm)
  E10_B_interno = circle(normal=Z, centre=(239.20917mm, 2.5091684mm, -4mm), radius=0.45975mm)
  E10_B_externo.subtract(E10_B_interno)
  RadiatingSurface [vacuum] = region(absolute_offset=19.646365mm on all sides)
boundaries and excitations:
  Cobre_35um: Finite Conductivity Objects=[Ant01_Crossover_Bridge, Ant01_Feed_A, Ant01_Feed_B_Inner, Ant01_Feed_B_Outer, Ant01_PadB0, Ant01_PadB1, Ant01_Ring_Q1..Ant01_Ring_Q4, Ant02_Crossover_Bridge, Ant02_Feed_A, Ant02_Feed_B_Inner, Ant02_Feed_B_Outer, Ant02_PadB0, Ant02_PadB1, Ant02_Ring_Q1..Ant02_Ring_Q4, Ant03_Crossover_Bridge, Ant03_Feed_A, Ant03_Feed_B_Inner, Ant03_Feed_B_Outer, Ant03_PadB0, Ant03_PadB1, Ant03_Ring_Q1..Ant03_Ring_Q4, Ant04_Crossover_Bridge, Ant04_Feed_A, Ant04_Feed_B_Inner, Ant04_Feed_B_Outer, Ant04_PadB0, Ant04_PadB1, Ant04_Ring_Q1..Ant04_Ring_Q4, Ant05_Crossover_Bridge, Ant05_Feed_A, Ant05_Feed_B_Inner, Ant05_Feed_B_Outer, Ant05_PadB0, Ant05_PadB1, Ant05_Ring_Q1..Ant05_Ring_Q4, Ant06_Crossover_Bridge, Ant06_Feed_A, Ant06_Feed_B_Inner, Ant06_Feed_B_Outer, Ant06_PadB0, Ant06_PadB1, Ant06_Ring_Q1..Ant06_Ring_Q4, Ant07_Crossover_Bridge, Ant07_Feed_A, Ant07_Feed_B_Inner, Ant07_Feed_B_Outer, Ant07_PadB0, Ant07_PadB1, Ant07_Ring_Q1..Ant07_Ring_Q4, Ant08_Crossover_Bridge, Ant08_Feed_A, Ant08_Feed_B_Inner, Ant08_Feed_B_Outer, Ant08_PadB0, Ant08_PadB1, Ant08_Ring_Q1..Ant08_Ring_Q4, Ant09_Crossover_Bridge, Ant09_Feed_A, Ant09_Feed_B_Inner, Ant09_Feed_B_Outer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] UseMaterial Material=copper Thickness=0.035mm Roughness=0.5um IsInternal
  Open1: Radiation Objects=RadiatingSurface
  E01_A: Lumped Port Objects=E01_A_externo LumpedPortType=Modal Modes{Mode1{IntLine{(-233.73108, -2.5091684, -4) -> (-232.67583, -2.5091684, -4)} CharImp=Zpi RenormImp=50ohm}} Impedance=50ohm
  E01_B: Lumped Port Objects=E01_B_externo LumpedPortType=Modal Modes{Mode1{IntLine{(-233.73108, 2.5091684, -4) -> (-232.67583, 2.5091684, -4)} CharImp=Zpi RenormImp=50ohm}} Impedance=50ohm
  E02_A: Lumped Port Objects=E02_A_externo LumpedPortType=Modal Modes{Mode1{IntLine{(-181.13108, -2.5091684, -4) -> (-180.07583, -2.5091684, -4)} CharImp=Zpi RenormImp=50ohm}} Impedance=50ohm
  E02_B: Lumped Port Objects=E02_B_externo LumpedPortType=Modal Modes{Mode1{IntLine{(-181.13108, 2.5091684, -4) -> (-180.07583, 2.5091684, -4)} CharImp=Zpi RenormImp=50ohm}} Impedance=50ohm
  E03_A: Lumped Port Objects=E03_A_externo LumpedPortType=Modal Modes{Mode1{IntLine{(-128.53108, -2.5091684, -4) -> (-127.47583, -2.5091684, -4)} CharImp=Zpi RenormImp=50ohm}} Impedance=50ohm
  E03_B: Lumped Port Objects=E03_B_externo LumpedPortType=Modal Modes{Mode1{IntLine{(-128.53108, 2.5091684, -4) -> (-127.47583, 2.5091684, -4)} CharImp=Zpi RenormImp=50ohm}} Impedance=50ohm
  E04_A: Lumped Port Objects=E04_A_externo LumpedPortType=Modal Modes{Mode1{IntLine{(-75.931082, -2.5091684, -4) -> (-74.875832, -2.5091684, -4)} CharImp=Zpi RenormImp=50ohm}} Impedance=50ohm
  E04_B: Lumped Port Objects=E04_B_externo LumpedPortType=Modal Modes{Mode1{IntLine{(-75.931082, 2.5091684, -4) -> (-74.875832, 2.5091684, -4)} CharImp=Zpi RenormImp=50ohm}} Impedance=50ohm
  E05_A: Lumped Port Objects=E05_A_externo LumpedPortType=Modal Modes{Mode1{IntLine{(-23.331082, -2.5091684, -4) -> (-22.275832, -2.5091684, -4)} CharImp=Zpi RenormImp=50ohm}} Impedance=50ohm
  E05_B: Lumped Port Objects=E05_B_externo LumpedPortType=Modal Modes{Mode1{IntLine{(-23.331082, 2.5091684, -4) -> (-22.275832, 2.5091684, -4)} CharImp=Zpi RenormImp=50ohm}} Impedance=50ohm
  E06_A: Lumped Port Objects=E06_A_externo LumpedPortType=Modal Modes{Mode1{IntLine{(29.268918, -2.5091684, -4) -> (30.324168, -2.5091684, -4)} CharImp=Zpi RenormImp=50ohm}} Impedance=50ohm
  E06_B: Lumped Port Objects=E06_B_externo LumpedPortType=Modal Modes{Mode1{IntLine{(29.268918, 2.5091684, -4) -> (30.324168, 2.5091684, -4)} CharImp=Zpi RenormImp=50ohm}} Impedance=50ohm
  E07_A: Lumped Port Objects=E07_A_externo LumpedPortType=Modal Modes{Mode1{IntLine{(81.868918, -2.5091684, -4) -> (82.924168, -2.5091684, -4)} CharImp=Zpi RenormImp=50ohm}} Impedance=50ohm
  E07_B: Lumped Port Objects=E07_B_externo LumpedPortType=Modal Modes{Mode1{IntLine{(81.868918, 2.5091684, -4) -> (82.924168, 2.5091684, -4)} CharImp=Zpi RenormImp=50ohm}} Impedance=50ohm
  E08_A: Lumped Port Objects=E08_A_externo LumpedPortType=Modal Modes{Mode1{IntLine{(134.46892, -2.5091684, -4) -> (135.52417, -2.5091684, -4)} CharImp=Zpi RenormImp=50ohm}} Impedance=50ohm
  E08_B: Lumped Port Objects=E08_B_externo LumpedPortType=Modal Modes{Mode1{IntLine{(134.46892, 2.5091684, -4) -> (135.52417, 2.5091684, -4)} CharImp=Zpi RenormImp=50ohm}} Impedance=50ohm
  E09_A: Lumped Port Objects=E09_A_externo LumpedPortType=Modal Modes{Mode1{IntLine{(187.06892, -2.5091684, -4) -> (188.12417, -2.5091684, -4)} CharImp=Zpi RenormImp=50ohm}} Impedance=50ohm
  E09_B: Lumped Port Objects=E09_B_externo LumpedPortType=Modal Modes{Mode1{IntLine{(187.06892, 2.5091684, -4) -> (188.12417, 2.5091684, -4)} CharImp=Zpi RenormImp=50ohm}} Impedance=50ohm
  E10_A: Lumped Port Objects=E10_A_externo LumpedPortType=Modal Modes{Mode1{IntLine{(239.66892, -2.5091684, -4) -> (240.72417, -2.5091684, -4)} CharImp=Zpi RenormImp=50ohm}} Impedance=50ohm
  E10_B: Lumped Port Objects=E10_B_externo LumpedPortType=Modal Modes{Mode1{IntLine{(239.66892, 2.5091684, -4) -> (240.72417, 2.5091684, -4)} CharImp=Zpi RenormImp=50ohm}} Impedance=50ohm
setups:
  Centro: HfssDriven Frequency=5.17GHz MaxDeltaS=0.012 MaximumPasses=16 MinimumPasses=3 MinimumConvergedPasses=2 PercentRefinement=20 BasisOrder=-1 PortAccuracy=2 DrivenSolverType="Iterative Solver" IterativeResidual=1e-05 DDMSolverResidual=1e-05
source amplitudes:
  E01_A:1, E01_B:1, E02_A:1, E02_B:1, E03_A:1, E03_B:1, E04_A:1, E04_B:1, E05_A:1, E05_B:1, E06_A:1, E06_B:1, E07_A:1, E07_B:1, E08_A:1, E08_B:1, E09_A:1, E09_B:1, E10_A:1, E10_B:1: 0.05W 0deg
radiation setups:
  3D: Infinite Sphere Theta=0deg..180deg step 2deg Phi=-180deg..180deg step 2deg
  Elevation: Infinite Sphere Theta=-180deg..180deg step 1deg Phi=0deg..90deg step 90deg
  Azimuth: Infinite Sphere Theta=90deg..90deg step 0deg Phi=-180deg..180deg step 1deg
  HV: Infinite Sphere Theta=-180deg..180deg step 0.25deg Phi=0deg..90deg step 90deg
reports:
  H: dB(RealizedGainTotal), dB(GainTotal), dB(DirTotal) vs Theta on Centro : LastAdaptive, HV [Phi=90deg Freq=5.17GHz]
  V: dB(RealizedGainTotal), dB(GainTotal), dB(DirTotal) vs Theta on Centro : LastAdaptive, HV [Phi=0deg Freq=5.17GHz]
