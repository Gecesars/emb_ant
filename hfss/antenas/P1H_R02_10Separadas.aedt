# Ansys Electronics Desktop project, version 2024.2
materials:
  vacuum: permittivity=1
  POM_nom: permittivity=3.4 dielectric_loss_tangent=0.01
  PTFE_cabo: permittivity=2.0363635 dielectric_loss_tangent=0.00027683055
  RO4350B_R01: permittivity=3.66 dielectric_loss_tangent=0.0037
  PE_nom: permittivity=2.3 dielectric_loss_tangent=0.001
  ZYF300: permittivity=2.94 dielectric_loss_tangent=0.0016
  Silicone_nom: permittivity=2.77 dielectric_loss_tangent=0.02
  AL5052: conductivity=20000000
  aco_nom: conductivity=1400000
  SAC305: conductivity=7575758
  latao_nom: conductivity=16000000
  copper: permeability=0.999991 conductivity=58000000

design Painel_montado (HFSS, HFSS Hybrid Modal Network, model units mm)
geometry:
  AL5052 [AL5052] = imported_body(D:\dev\EMBRAER/P1H/R02_Separadas\cad\AL5052.step)
  Termorretratil_N_B, Termorretratil_N_A [PE_nom] = imported_body(D:\dev\EMBRAER/P1H/R02_Separadas\cad\PE_nom.step)
  Trilho_RAIZ_D, Trilho_RAIZ_E, Trilho_SUP_D, Trilho_SUP_E, Trilho_INF_D, Trilho_INF_E, Batente_7, Batente_6, Berco_5, Berco_4, Berco_3, Berco_2, Berco_1, Guia_PCB_D, Guia_PCB_E [POM_nom] = imported_body(D:\dev\EMBRAER/P1H/R02_Separadas\cad\POM_nom.step)
  Isol_IN_B, Isol_IN_A, Isol_TR_SUP_B, Isol_TR_SUP_A, Isol_TR_INF_B, Isol_TR_INF_A, Isol_SUP_B3, Isol_SUP_A3, Isol_SUP_B4, Isol_SUP_B2, Isol_SUP_A4, Isol_SUP_A2, Isol_SUP_B5, Isol_SUP_B1, Isol_SUP_A5, Isol_SUP_A1, Isol_INF_B3, Isol_INF_A3, Isol_INF_B4, Isol_INF_B2, Isol_INF_A4, Isol_INF_A2, Isol_INF_B5, Isol_INF_B1, Isol_INF_A5, Isol_INF_A1, N_isol_B, N_isol_A [PTFE_cabo] = imported_body(D:\dev\EMBRAER/P1H/R02_Separadas\cad\PTFE_cabo.step)
  Rogers_E10, Rogers_E09, Rogers_E08, Rogers_E07, Rogers_E06, Rogers_E05, Rogers_E04, Rogers_E03, Rogers_E02, Rogers_E01 [RO4350B_R01] = imported_body(D:\dev\EMBRAER/P1H/R02_Separadas\cad\RO4350B_R01.step)
  Solda_Superior_B5, Solda_Superior_B4, Solda_Superior_B3, Solda_Superior_B2, Solda_Superior_B1, Solda_Superior_B_IN, Solda_Superior_A5, Solda_Superior_A4, Solda_Superior_A3, Solda_Superior_A2, Solda_Superior_A1, Solda_Superior_A_IN, Solda_Inferior_RB2, Solda_Inferior_RB1, Solda_Inferior_RA2, Solda_Inferior_RA1, Solda_Inferior_B5, Solda_Inferior_B4, Solda_Inferior_B3, Solda_Inferior_B2, Solda_Inferior_B1, Solda_Inferior_B_IN, Solda_Inferior_A5, Solda_Inferior_A4, Solda_Inferior_A3, Solda_Inferior_A2, Solda_Inferior_A1, Solda_Inferior_A_IN [SAC305] = imported_body(D:\dev\EMBRAER/P1H/R02_Separadas\cad\SAC305.step)
  Junta_N_B, Junta_N_A, Passa_cabos_10, Passa_cabos_09, Passa_cabos_08, Passa_cabos_07, Passa_cabos_06, Passa_cabos_05, Passa_cabos_04, Passa_cabos_03, Passa_cabos_02, Passa_cabos_01 [Silicone_nom] = imported_body(D:\dev\EMBRAER/P1H/R02_Separadas\cad\Silicone_nom.step)
  PCB_Superior, PCB_Inferior [ZYF300] = imported_body(D:\dev\EMBRAER/P1H/R02_Separadas\cad\ZYF300.step)
  Trilho_RAIZ_D_par_1, Trilho_RAIZ_D_par_1_1, Trilho_RAIZ_D_par_0, Trilho_RAIZ_D_par_0_1, Trilho_RAIZ_E_par_1, Trilho_RAIZ_E_par_1_1, Trilho_RAIZ_E_par_0, Trilho_RAIZ_E_par_0_1, Trilho_SUP_D_par_1, Trilho_SUP_D_par_1_1, Trilho_SUP_D_par_0, Trilho_SUP_D_par_0_1, Trilho_SUP_E_par_1, Trilho_SUP_E_par_1_1, Trilho_SUP_E_par_0, Trilho_SUP_E_par_0_1, Trilho_INF_D_par_1, Trilho_INF_D_par_1_1, Trilho_INF_D_par_0, Trilho_INF_D_par_0_1, Trilho_INF_E_par_1, Trilho_INF_E_par_1_1, Trilho_INF_E_par_0, Trilho_INF_E_par_0_1, Par_6_1, Par_6_1_1, Par_6_0, Par_6_0_1, Par_5_1, Par_5_1_1, Par_5_0, Par_5_0_1, Par_4_1, Par_4_1_1, Par_4_0, Par_4_0_1, Par_3_1, Par_3_1_1, Par_3_0, Par_3_0_1, Par_2_1, Par_2_1_1, Par_2_0, Par_2_0_1, Par_1_1, Par_1_1_1, Par_1_0, Par_1_0_1, Par_0_1, Par_0_1_1, Par_0_0, Par_0_0_1 [aco_nom] = imported_body(D:\dev\EMBRAER/P1H/R02_Separadas\cad\aco_nom.step)
  Lancamento_B, Lancamento_A, Capa_TR_SUP_B, Sinal_TR_SUP_B, Capa_TR_SUP_A, Sinal_TR_SUP_A, Capa_TR_INF_B, Sinal_TR_INF_B, Capa_TR_INF_A, Sinal_TR_INF_A, Capa_SUP_B3, Sinal_SUP_B3, Capa_SUP_A3, Sinal_SUP_A3, Capa_SUP_B4, Sinal_SUP_B4, Capa_SUP_B2, Sinal_SUP_B2, Capa_SUP_A4, Sinal_SUP_A4, Capa_SUP_A2, Sinal_SUP_A2, Capa_SUP_B5, Sinal_SUP_B5, Capa_SUP_B1, Sinal_SUP_B1, Capa_SUP_A5, Sinal_SUP_A5, Capa_SUP_A1, Sinal_SUP_A1, Capa_INF_B3, Sinal_INF_B3, Capa_INF_A3, Sinal_INF_A3, Capa_INF_B4, Sinal_INF_B4, Capa_INF_B2, Sinal_INF_B2, Capa_INF_A4, Sinal_INF_A4, Capa_INF_A2, Sinal_INF_A2, Capa_INF_B5, Sinal_INF_B5, Capa_INF_B1, Sinal_INF_B1, Capa_INF_A5, Sinal_INF_A5, Capa_INF_A1, Sinal_INF_A1, Via09_1, Via09_0, Via08_1, Via08_0, Via07_1, Via07_0, Via06_1, Via06_0, Via05_1, Via05_0, Via04_1, Via04_0, Via03_1, Via03_0, Via02_1, Via02_0, Via01_1, Via01_0, Via00_1, Via00_0 [copper] = imported_body(D:\dev\EMBRAER/P1H/R02_Separadas\cad\copper.step)
  Estrela_Superior_B, Estrela_Superior_A, Massa_Superior, Pad_Superior_B5, Pad_Superior_B4, Pad_Superior_B3, Pad_Superior_B2, Pad_Superior_B1, Pad_Superior_B_IN, Pad_Superior_A5, Pad_Superior_A4, Pad_Superior_A3, Pad_Superior_A2, Pad_Superior_A1, Pad_Superior_A_IN, Estrela_Inferior_RB, Estrela_Inferior_RA, Estrela_Inferior_B, Estrela_Inferior_A, Massa_Inferior, Pad_Inferior_RB2, Pad_Inferior_RB1, Pad_Inferior_RB_IN, Pad_Inferior_RA2, Pad_Inferior_RA1, Pad_Inferior_RA_IN, Pad_Inferior_B5, Pad_Inferior_B4, Pad_Inferior_B3, Pad_Inferior_B2, Pad_Inferior_B1, Pad_Inferior_B_IN, Pad_Inferior_A5, Pad_Inferior_A4, Pad_Inferior_A3, Pad_Inferior_A2, Pad_Inferior_A1, Pad_Inferior_A_IN, Ant10_PadB1, Ant10_PadB0, Ant10_Feed_B_Inner, Ant10_Feed_B_Outer, Ant10_Feed_A, Ant10_Crossover_Bridge, Ant10_Ring_Q4, Ant10_Ring_Q3, Ant10_Ring_Q2, Ant10_Ring_Q1, Ant09_PadB1, Ant09_PadB0, Ant09_Feed_B_Inner, Ant09_Feed_B_Outer, Ant09_Feed_A, Ant09_Crossover_Bridge, Ant09_Ring_Q4, Ant09_Ring_Q3, Ant09_Ring_Q2, Ant09_Ring_Q1, Ant08_PadB1, Ant08_PadB0, Ant08_Feed_B_Inner, Ant08_Feed_B_Outer, Ant08_Feed_A, Ant08_Crossover_Bridge, Ant08_Ring_Q4, Ant08_Ring_Q3, Ant08_Ring_Q2, Ant08_Ring_Q1, Ant07_PadB1, Ant07_PadB0, Ant07_Feed_B_Inner, Ant07_Feed_B_Outer, Ant07_Feed_A, Ant07_Crossover_Bridge, Ant07_Ring_Q4, Ant07_Ring_Q3, Ant07_Ring_Q2, Ant07_Ring_Q1, Ant06_PadB1, Ant06_PadB0, Ant06_Feed_B_Inner, Ant06_Feed_B_Outer, Ant06_Feed_A, Ant06_Crossover_Bridge, Ant06_Ring_Q4, Ant06_Ring_Q3, Ant06_Ring_Q2, Ant06_Ring_Q1, Ant05_PadB1, Ant05_PadB0, Ant05_Feed_B_Inner, Ant05_Feed_B_Outer, Ant05_Feed_A, Ant05_Crossover_Bridge, Ant05_Ring_Q4, Ant05_Ring_Q3, Ant05_Ring_Q2, Ant05_Ring_Q1, Ant04_PadB1, Ant04_PadB0, Ant04_Feed_B_Inner, Ant04_Feed_B_Outer, Ant04_Feed_A, Ant04_Crossover_Bridge, Ant04_Ring_Q4, Ant04_Ring_Q3, Ant04_Ring_Q2, Ant04_Ring_Q1, Ant03_PadB1, Ant03_PadB0, Ant03_Feed_B_Inner, Ant03_Feed_B_Outer, Ant03_Feed_A, Ant03_Crossover_Bridge, Ant03_Ring_Q4, Ant03_Ring_Q3, Ant03_Ring_Q2, Ant03_Ring_Q1, Ant02_PadB1, Ant02_PadB0, Ant02_Feed_B_Inner, Ant02_Feed_B_Outer, Ant02_Feed_A, Ant02_Crossover_Bridge, Ant02_Ring_Q4, Ant02_Ring_Q3, Ant02_Ring_Q2, Ant02_Ring_Q1, Ant01_PadB1, Ant01_PadB0, Ant01_Feed_B_Inner, Ant01_Feed_B_Outer, Ant01_Feed_A, Ant01_Crossover_Bridge, Ant01_Ring_Q4, Ant01_Ring_Q3, Ant01_Ring_Q2, Ant01_Ring_Q1 = imported_body(D:\dev\EMBRAER/P1H/R02_Separadas\cad\folha_cu.step)
  N_pino_B, N_corpo_B, N_pino_A, N_corpo_A [latao_nom] = imported_body(D:\dev\EMBRAER/P1H/R02_Separadas\cad\latao_nom.step)
  Plano_N_A = circle(normal=X, centre=(-288mm, -19.25mm, -31mm), radius=3.5mm)
  Miolo_A = circle(normal=X, centre=(-288mm, -19.25mm, -31mm), radius=1.5217391mm)
  Plano_N_A.subtract(Miolo_A)
  Plano_N_B = circle(normal=X, centre=(-288mm, 19.25mm, -31mm), radius=3.5mm)
  Miolo_B = circle(normal=X, centre=(-288mm, 19.25mm, -31mm), radius=1.5217391mm)
  Plano_N_B.subtract(Miolo_B)
  RadiatingSurface [vacuum] = region(absolute_offset=19.646365mm on all sides)
boundaries and excitations:
  Metais_impressos_35um: Finite Conductivity Objects=[Ant01_Crossover_Bridge, Ant01_Feed_A, Ant01_Feed_B_Inner, Ant01_Feed_B_Outer, Ant01_PadB0, Ant01_PadB1, Ant01_Ring_Q1..Ant01_Ring_Q4, Ant02_Crossover_Bridge, Ant02_Feed_A, Ant02_Feed_B_Inner, Ant02_Feed_B_Outer, Ant02_PadB0, Ant02_PadB1, Ant02_Ring_Q1..Ant02_Ring_Q4, Ant03_Crossover_Bridge, Ant03_Feed_A, Ant03_Feed_B_Inner, Ant03_Feed_B_Outer, Ant03_PadB0, Ant03_PadB1, Ant03_Ring_Q1..Ant03_Ring_Q4, Ant04_Crossover_Bridge, Ant04_Feed_A, Ant04_Feed_B_Inner, Ant04_Feed_B_Outer, Ant04_PadB0, Ant04_PadB1, Ant04_Ring_Q1..Ant04_Ring_Q4, Ant05_Crossover_Bridge, Ant05_Feed_A, Ant05_Feed_B_Inner, Ant05_Feed_B_Outer, Ant05_PadB0, Ant05_PadB1, Ant05_Ring_Q1..Ant05_Ring_Q4, Ant06_Crossover_Bridge, Ant06_Feed_A, Ant06_Feed_B_Inner, Ant06_Feed_B_Outer, Ant06_PadB0, Ant06_PadB1, Ant06_Ring_Q1..Ant06_Ring_Q4, Ant07_Crossover_Bridge, Ant07_Feed_A, Ant07_Feed_B_Inner, Ant07_Feed_B_Outer, Ant07_PadB0, Ant07_PadB1, Ant07_Ring_Q1..Ant07_Ring_Q4, Ant08_Crossover_Bridge, Ant08_Feed_A, Ant08_Feed_B_Inner, Ant08_Feed_B_Outer, Ant08_PadB0, Ant08_PadB1, Ant08_Ring_Q1..Ant08_Ring_Q4, Ant09_Crossover_Bridge, Ant09_Feed_A, Ant09_Feed_B_Inner, Ant09_Feed_B_Outer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] UseMaterial Material=copper Thickness=0.035mm Roughness=0.5um IsInternal
  Open1: Radiation Objects=RadiatingSurface
  N_A: Lumped Port Objects=Plano_N_A LumpedPortType=Modal Modes{Mode1{IntLine{(-288, -17.728261, -31) -> (-288, -15.75, -31)} CharImp=Zpi RenormImp=50ohm}} Impedance=50ohm
  N_B: Lumped Port Objects=Plano_N_B LumpedPortType=Modal Modes{Mode1{IntLine{(-288, 20.771739, -31) -> (-288, 22.75, -31)} CharImp=Zpi RenormImp=50ohm}} Impedance=50ohm
mesh:
  initial mesh: GlobalSurfApproximation{CurvedSurfaceApproxChoice=ManualSettings SurfDev=0.035mm NormalDev=25deg AspectRatio=25} GlobalCurvilinear{Apply} GlobalModelRes{DefeatureLength=0.002mm} MeshMethod=AnsoftTAU UseFlexMeshingForTAUvolumeMesh
setups:
  Banda: HfssDriven Frequency=5.17GHz MaxDeltaS=0.015 MaximumPasses=15 MinimumPasses=3 MinimumConvergedPasses=2 PercentRefinement=15 BasisOrder=0 PortAccuracy=2 DrivenSolverType="Iterative Solver" IterativeResidual=1e-05 DDMSolverResidual=1e-05
source amplitudes:
  N_A:1, N_B:1: 0.5W 0deg
radiation setups:
  3D: Infinite Sphere Theta=0deg..180deg step 2deg Phi=-180deg..180deg step 2deg
  Elevation: Infinite Sphere Theta=-180deg..180deg step 1deg Phi=0deg..90deg step 90deg
  Azimuth: Infinite Sphere Theta=90deg..90deg step 0deg Phi=-180deg..180deg step 1deg
  HV: Infinite Sphere Theta=-180deg..180deg step 0.25deg Phi=0deg..90deg step 90deg
